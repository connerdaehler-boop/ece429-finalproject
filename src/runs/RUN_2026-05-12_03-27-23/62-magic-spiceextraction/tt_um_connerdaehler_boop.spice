* NGSPICE file created from tt_um_connerdaehler_boop.ext - technology: sky130A

* Black-box entry subcircuit for sky130_fd_sc_hd__o21ai_1 abstract view
.subckt sky130_fd_sc_hd__o21ai_1 A1 A2 B1 VGND VNB VPB VPWR Y
.ends

* Black-box entry subcircuit for sky130_fd_sc_hd__fill_2 abstract view
.subckt sky130_fd_sc_hd__fill_2 VGND VNB VPB VPWR
.ends

* Black-box entry subcircuit for sky130_fd_sc_hd__xnor2_1 abstract view
.subckt sky130_fd_sc_hd__xnor2_1 A B VGND VNB VPB VPWR Y
.ends

* Black-box entry subcircuit for sky130_fd_sc_hd__decap_3 abstract view
.subckt sky130_fd_sc_hd__decap_3 VGND VNB VPB VPWR
.ends

* Black-box entry subcircuit for sky130_fd_sc_hd__tapvpwrvgnd_1 abstract view
.subckt sky130_fd_sc_hd__tapvpwrvgnd_1 VGND VPWR
.ends

* Black-box entry subcircuit for sky130_fd_sc_hd__fill_1 abstract view
.subckt sky130_fd_sc_hd__fill_1 VGND VNB VPB VPWR
.ends

* Black-box entry subcircuit for sky130_fd_sc_hd__xnor2_4 abstract view
.subckt sky130_fd_sc_hd__xnor2_4 A B VGND VNB VPB VPWR Y
.ends

* Black-box entry subcircuit for sky130_fd_sc_hd__o22a_1 abstract view
.subckt sky130_fd_sc_hd__o22a_1 A1 A2 B1 B2 VGND VNB VPB VPWR X
.ends

* Black-box entry subcircuit for sky130_fd_sc_hd__a21o_1 abstract view
.subckt sky130_fd_sc_hd__a21o_1 A1 A2 B1 VGND VNB VPB VPWR X
.ends

* Black-box entry subcircuit for sky130_fd_sc_hd__and3_1 abstract view
.subckt sky130_fd_sc_hd__and3_1 A B C VGND VNB VPB VPWR X
.ends

* Black-box entry subcircuit for sky130_fd_sc_hd__nand2_1 abstract view
.subckt sky130_fd_sc_hd__nand2_1 A B VGND VNB VPB VPWR Y
.ends

* Black-box entry subcircuit for sky130_fd_sc_hd__or3_2 abstract view
.subckt sky130_fd_sc_hd__or3_2 A B C VGND VNB VPB VPWR X
.ends

* Black-box entry subcircuit for sky130_fd_sc_hd__nor3_1 abstract view
.subckt sky130_fd_sc_hd__nor3_1 A B C VGND VNB VPB VPWR Y
.ends

* Black-box entry subcircuit for sky130_fd_sc_hd__xor2_1 abstract view
.subckt sky130_fd_sc_hd__xor2_1 A B VGND VNB VPB VPWR X
.ends

* Black-box entry subcircuit for sky130_fd_sc_hd__nor2_1 abstract view
.subckt sky130_fd_sc_hd__nor2_1 A B VGND VNB VPB VPWR Y
.ends

* Black-box entry subcircuit for sky130_fd_sc_hd__and2_1 abstract view
.subckt sky130_fd_sc_hd__and2_1 A B VGND VNB VPB VPWR X
.ends

* Black-box entry subcircuit for sky130_fd_sc_hd__inv_2 abstract view
.subckt sky130_fd_sc_hd__inv_2 A VGND VNB VPB VPWR Y
.ends

* Black-box entry subcircuit for sky130_fd_sc_hd__or3b_1 abstract view
.subckt sky130_fd_sc_hd__or3b_1 A B C_N VGND VNB VPB VPWR X
.ends

* Black-box entry subcircuit for sky130_fd_sc_hd__a21oi_1 abstract view
.subckt sky130_fd_sc_hd__a21oi_1 A1 A2 B1 VGND VNB VPB VPWR Y
.ends

* Black-box entry subcircuit for sky130_fd_sc_hd__o21ba_1 abstract view
.subckt sky130_fd_sc_hd__o21ba_1 A1 A2 B1_N VGND VNB VPB VPWR X
.ends

* Black-box entry subcircuit for sky130_fd_sc_hd__conb_1 abstract view
.subckt sky130_fd_sc_hd__conb_1 VGND VNB VPB VPWR HI LO
.ends

* Black-box entry subcircuit for sky130_fd_sc_hd__o2111a_1 abstract view
.subckt sky130_fd_sc_hd__o2111a_1 A1 A2 B1 C1 D1 VGND VNB VPB VPWR X
.ends

* Black-box entry subcircuit for sky130_fd_sc_hd__a21bo_1 abstract view
.subckt sky130_fd_sc_hd__a21bo_1 A1 A2 B1_N VGND VNB VPB VPWR X
.ends

* Black-box entry subcircuit for sky130_fd_sc_hd__a31oi_1 abstract view
.subckt sky130_fd_sc_hd__a31oi_1 A1 A2 A3 B1 VGND VNB VPB VPWR Y
.ends

* Black-box entry subcircuit for sky130_fd_sc_hd__nand2b_1 abstract view
.subckt sky130_fd_sc_hd__nand2b_1 A_N B VGND VNB VPB VPWR Y
.ends

* Black-box entry subcircuit for sky130_fd_sc_hd__a311oi_1 abstract view
.subckt sky130_fd_sc_hd__a311oi_1 A1 A2 A3 B1 C1 VGND VNB VPB VPWR Y
.ends

* Black-box entry subcircuit for sky130_fd_sc_hd__or3_1 abstract view
.subckt sky130_fd_sc_hd__or3_1 A B C VGND VNB VPB VPWR X
.ends

* Black-box entry subcircuit for sky130_fd_sc_hd__o31a_1 abstract view
.subckt sky130_fd_sc_hd__o31a_1 A1 A2 A3 B1 VGND VNB VPB VPWR X
.ends

* Black-box entry subcircuit for sky130_fd_sc_hd__buf_1 abstract view
.subckt sky130_fd_sc_hd__buf_1 A VGND VNB VPB VPWR X
.ends

* Black-box entry subcircuit for sky130_fd_sc_hd__o2bb2a_2 abstract view
.subckt sky130_fd_sc_hd__o2bb2a_2 A1_N A2_N B1 B2 VGND VNB VPB VPWR X
.ends

* Black-box entry subcircuit for sky130_fd_sc_hd__o2bb2a_1 abstract view
.subckt sky130_fd_sc_hd__o2bb2a_1 A1_N A2_N B1 B2 VGND VNB VPB VPWR X
.ends

* Black-box entry subcircuit for sky130_fd_sc_hd__o21bai_2 abstract view
.subckt sky130_fd_sc_hd__o21bai_2 A1 A2 B1_N VGND VNB VPB VPWR Y
.ends

* Black-box entry subcircuit for sky130_fd_sc_hd__nor3_2 abstract view
.subckt sky130_fd_sc_hd__nor3_2 A B C VGND VNB VPB VPWR Y
.ends

* Black-box entry subcircuit for sky130_fd_sc_hd__o32a_1 abstract view
.subckt sky130_fd_sc_hd__o32a_1 A1 A2 A3 B1 B2 VGND VNB VPB VPWR X
.ends

* Black-box entry subcircuit for sky130_fd_sc_hd__and2b_1 abstract view
.subckt sky130_fd_sc_hd__and2b_1 A_N B VGND VNB VPB VPWR X
.ends

* Black-box entry subcircuit for sky130_fd_sc_hd__a21oi_2 abstract view
.subckt sky130_fd_sc_hd__a21oi_2 A1 A2 B1 VGND VNB VPB VPWR Y
.ends

* Black-box entry subcircuit for sky130_fd_sc_hd__xor2_4 abstract view
.subckt sky130_fd_sc_hd__xor2_4 A B VGND VNB VPB VPWR X
.ends

* Black-box entry subcircuit for sky130_fd_sc_hd__a211oi_1 abstract view
.subckt sky130_fd_sc_hd__a211oi_1 A1 A2 B1 C1 VGND VNB VPB VPWR Y
.ends

* Black-box entry subcircuit for sky130_fd_sc_hd__xnor2_2 abstract view
.subckt sky130_fd_sc_hd__xnor2_2 A B VGND VNB VPB VPWR Y
.ends

* Black-box entry subcircuit for sky130_fd_sc_hd__o21a_1 abstract view
.subckt sky130_fd_sc_hd__o21a_1 A1 A2 B1 VGND VNB VPB VPWR X
.ends

* Black-box entry subcircuit for sky130_fd_sc_hd__a211oi_2 abstract view
.subckt sky130_fd_sc_hd__a211oi_2 A1 A2 B1 C1 VGND VNB VPB VPWR Y
.ends

* Black-box entry subcircuit for sky130_fd_sc_hd__a31o_1 abstract view
.subckt sky130_fd_sc_hd__a31o_1 A1 A2 A3 B1 VGND VNB VPB VPWR X
.ends

* Black-box entry subcircuit for sky130_fd_sc_hd__and3_2 abstract view
.subckt sky130_fd_sc_hd__and3_2 A B C VGND VNB VPB VPWR X
.ends

* Black-box entry subcircuit for sky130_fd_sc_hd__or2_1 abstract view
.subckt sky130_fd_sc_hd__or2_1 A B VGND VNB VPB VPWR X
.ends

* Black-box entry subcircuit for sky130_fd_sc_hd__o21ai_2 abstract view
.subckt sky130_fd_sc_hd__o21ai_2 A1 A2 B1 VGND VNB VPB VPWR Y
.ends

* Black-box entry subcircuit for sky130_fd_sc_hd__o311a_1 abstract view
.subckt sky130_fd_sc_hd__o311a_1 A1 A2 A3 B1 C1 VGND VNB VPB VPWR X
.ends

* Black-box entry subcircuit for sky130_fd_sc_hd__nand2_4 abstract view
.subckt sky130_fd_sc_hd__nand2_4 A B VGND VNB VPB VPWR Y
.ends

* Black-box entry subcircuit for sky130_fd_sc_hd__a211o_1 abstract view
.subckt sky130_fd_sc_hd__a211o_1 A1 A2 B1 C1 VGND VNB VPB VPWR X
.ends

* Black-box entry subcircuit for sky130_fd_sc_hd__clkbuf_8 abstract view
.subckt sky130_fd_sc_hd__clkbuf_8 A VGND VNB VPB VPWR X
.ends

* Black-box entry subcircuit for sky130_fd_sc_hd__a22o_1 abstract view
.subckt sky130_fd_sc_hd__a22o_1 A1 A2 B1 B2 VGND VNB VPB VPWR X
.ends

* Black-box entry subcircuit for sky130_fd_sc_hd__and2_2 abstract view
.subckt sky130_fd_sc_hd__and2_2 A B VGND VNB VPB VPWR X
.ends

* Black-box entry subcircuit for sky130_fd_sc_hd__o221a_1 abstract view
.subckt sky130_fd_sc_hd__o221a_1 A1 A2 B1 B2 C1 VGND VNB VPB VPWR X
.ends

* Black-box entry subcircuit for sky130_fd_sc_hd__and4bb_2 abstract view
.subckt sky130_fd_sc_hd__and4bb_2 A_N B_N C D VGND VNB VPB VPWR X
.ends

* Black-box entry subcircuit for sky130_fd_sc_hd__o211a_1 abstract view
.subckt sky130_fd_sc_hd__o211a_1 A1 A2 B1 C1 VGND VNB VPB VPWR X
.ends

* Black-box entry subcircuit for sky130_fd_sc_hd__o211ai_1 abstract view
.subckt sky130_fd_sc_hd__o211ai_1 A1 A2 B1 C1 VGND VNB VPB VPWR Y
.ends

* Black-box entry subcircuit for sky130_fd_sc_hd__o211ai_2 abstract view
.subckt sky130_fd_sc_hd__o211ai_2 A1 A2 B1 C1 VGND VNB VPB VPWR Y
.ends

* Black-box entry subcircuit for sky130_fd_sc_hd__a2bb2o_1 abstract view
.subckt sky130_fd_sc_hd__a2bb2o_1 A1_N A2_N B1 B2 VGND VNB VPB VPWR X
.ends

* Black-box entry subcircuit for sky130_fd_sc_hd__or2_2 abstract view
.subckt sky130_fd_sc_hd__or2_2 A B VGND VNB VPB VPWR X
.ends

* Black-box entry subcircuit for sky130_fd_sc_hd__nand3_1 abstract view
.subckt sky130_fd_sc_hd__nand3_1 A B C VGND VNB VPB VPWR Y
.ends

* Black-box entry subcircuit for sky130_fd_sc_hd__dfrtp_4 abstract view
.subckt sky130_fd_sc_hd__dfrtp_4 CLK D RESET_B VGND VNB VPB VPWR Q
.ends

* Black-box entry subcircuit for sky130_fd_sc_hd__o31ai_2 abstract view
.subckt sky130_fd_sc_hd__o31ai_2 A1 A2 A3 B1 VGND VNB VPB VPWR Y
.ends

* Black-box entry subcircuit for sky130_fd_sc_hd__nor2_2 abstract view
.subckt sky130_fd_sc_hd__nor2_2 A B VGND VNB VPB VPWR Y
.ends

* Black-box entry subcircuit for sky130_fd_sc_hd__clkbuf_16 abstract view
.subckt sky130_fd_sc_hd__clkbuf_16 A VGND VNB VPB VPWR X
.ends

* Black-box entry subcircuit for sky130_fd_sc_hd__dfrtp_2 abstract view
.subckt sky130_fd_sc_hd__dfrtp_2 CLK D RESET_B VGND VNB VPB VPWR Q
.ends

* Black-box entry subcircuit for sky130_fd_sc_hd__o31a_2 abstract view
.subckt sky130_fd_sc_hd__o31a_2 A1 A2 A3 B1 VGND VNB VPB VPWR X
.ends

* Black-box entry subcircuit for sky130_fd_sc_hd__dlymetal6s2s_1 abstract view
.subckt sky130_fd_sc_hd__dlymetal6s2s_1 A VGND VNB VPB VPWR X
.ends

* Black-box entry subcircuit for sky130_fd_sc_hd__o21bai_1 abstract view
.subckt sky130_fd_sc_hd__o21bai_1 A1 A2 B1_N VGND VNB VPB VPWR Y
.ends

* Black-box entry subcircuit for sky130_fd_sc_hd__mux2_1 abstract view
.subckt sky130_fd_sc_hd__mux2_1 A0 A1 S VGND VNB VPB VPWR X
.ends

* Black-box entry subcircuit for sky130_fd_sc_hd__xor2_2 abstract view
.subckt sky130_fd_sc_hd__xor2_2 A B VGND VNB VPB VPWR X
.ends

* Black-box entry subcircuit for sky130_fd_sc_hd__clkbuf_2 abstract view
.subckt sky130_fd_sc_hd__clkbuf_2 A VGND VNB VPB VPWR X
.ends

* Black-box entry subcircuit for sky130_fd_sc_hd__buf_4 abstract view
.subckt sky130_fd_sc_hd__buf_4 A VGND VNB VPB VPWR X
.ends

* Black-box entry subcircuit for sky130_fd_sc_hd__and3_4 abstract view
.subckt sky130_fd_sc_hd__and3_4 A B C VGND VNB VPB VPWR X
.ends

* Black-box entry subcircuit for sky130_fd_sc_hd__nand2_2 abstract view
.subckt sky130_fd_sc_hd__nand2_2 A B VGND VNB VPB VPWR Y
.ends

* Black-box entry subcircuit for sky130_fd_sc_hd__buf_2 abstract view
.subckt sky130_fd_sc_hd__buf_2 A VGND VNB VPB VPWR X
.ends

* Black-box entry subcircuit for sky130_fd_sc_hd__a31oi_2 abstract view
.subckt sky130_fd_sc_hd__a31oi_2 A1 A2 A3 B1 VGND VNB VPB VPWR Y
.ends

* Black-box entry subcircuit for sky130_fd_sc_hd__dfrtp_1 abstract view
.subckt sky130_fd_sc_hd__dfrtp_1 CLK D RESET_B VGND VNB VPB VPWR Q
.ends

* Black-box entry subcircuit for sky130_fd_sc_hd__clkbuf_1 abstract view
.subckt sky130_fd_sc_hd__clkbuf_1 A VGND VNB VPB VPWR X
.ends

* Black-box entry subcircuit for sky130_fd_sc_hd__nand3_2 abstract view
.subckt sky130_fd_sc_hd__nand3_2 A B C VGND VNB VPB VPWR Y
.ends

* Black-box entry subcircuit for sky130_fd_sc_hd__a21boi_1 abstract view
.subckt sky130_fd_sc_hd__a21boi_1 A1 A2 B1_N VGND VNB VPB VPWR Y
.ends

* Black-box entry subcircuit for sky130_fd_sc_hd__o2bb2ai_1 abstract view
.subckt sky130_fd_sc_hd__o2bb2ai_1 A1_N A2_N B1 B2 VGND VNB VPB VPWR Y
.ends

* Black-box entry subcircuit for sky130_fd_sc_hd__o311a_2 abstract view
.subckt sky130_fd_sc_hd__o311a_2 A1 A2 A3 B1 C1 VGND VNB VPB VPWR X
.ends

* Black-box entry subcircuit for sky130_fd_sc_hd__clkbuf_4 abstract view
.subckt sky130_fd_sc_hd__clkbuf_4 A VGND VNB VPB VPWR X
.ends

* Black-box entry subcircuit for sky130_fd_sc_hd__nand3b_1 abstract view
.subckt sky130_fd_sc_hd__nand3b_1 A_N B C VGND VNB VPB VPWR Y
.ends

* Black-box entry subcircuit for sky130_fd_sc_hd__o32ai_2 abstract view
.subckt sky130_fd_sc_hd__o32ai_2 A1 A2 A3 B1 B2 VGND VNB VPB VPWR Y
.ends

* Black-box entry subcircuit for sky130_fd_sc_hd__a21boi_2 abstract view
.subckt sky130_fd_sc_hd__a21boi_2 A1 A2 B1_N VGND VNB VPB VPWR Y
.ends

* Black-box entry subcircuit for sky130_fd_sc_hd__buf_12 abstract view
.subckt sky130_fd_sc_hd__buf_12 A VGND VNB VPB VPWR X
.ends

* Black-box entry subcircuit for sky130_fd_sc_hd__and3b_2 abstract view
.subckt sky130_fd_sc_hd__and3b_2 A_N B C VGND VNB VPB VPWR X
.ends

* Black-box entry subcircuit for sky130_fd_sc_hd__a21bo_2 abstract view
.subckt sky130_fd_sc_hd__a21bo_2 A1 A2 B1_N VGND VNB VPB VPWR X
.ends

* Black-box entry subcircuit for sky130_fd_sc_hd__o311ai_4 abstract view
.subckt sky130_fd_sc_hd__o311ai_4 A1 A2 A3 B1 C1 VGND VNB VPB VPWR Y
.ends

* Black-box entry subcircuit for sky130_fd_sc_hd__and3b_1 abstract view
.subckt sky130_fd_sc_hd__and3b_1 A_N B C VGND VNB VPB VPWR X
.ends

* Black-box entry subcircuit for sky130_fd_sc_hd__a21o_2 abstract view
.subckt sky130_fd_sc_hd__a21o_2 A1 A2 B1 VGND VNB VPB VPWR X
.ends

* Black-box entry subcircuit for sky130_fd_sc_hd__a221o_1 abstract view
.subckt sky130_fd_sc_hd__a221o_1 A1 A2 B1 B2 C1 VGND VNB VPB VPWR X
.ends

* Black-box entry subcircuit for sky130_fd_sc_hd__and4b_4 abstract view
.subckt sky130_fd_sc_hd__and4b_4 A_N B C D VGND VNB VPB VPWR X
.ends

* Black-box entry subcircuit for sky130_fd_sc_hd__nand2b_2 abstract view
.subckt sky130_fd_sc_hd__nand2b_2 A_N B VGND VNB VPB VPWR Y
.ends

* Black-box entry subcircuit for sky130_fd_sc_hd__dlygate4sd3_1 abstract view
.subckt sky130_fd_sc_hd__dlygate4sd3_1 A VGND VNB VPB VPWR X
.ends

* Black-box entry subcircuit for sky130_fd_sc_hd__and4b_2 abstract view
.subckt sky130_fd_sc_hd__and4b_2 A_N B C D VGND VNB VPB VPWR X
.ends

* Black-box entry subcircuit for sky130_fd_sc_hd__nand4_1 abstract view
.subckt sky130_fd_sc_hd__nand4_1 A B C D VGND VNB VPB VPWR Y
.ends

* Black-box entry subcircuit for sky130_fd_sc_hd__o21ai_4 abstract view
.subckt sky130_fd_sc_hd__o21ai_4 A1 A2 B1 VGND VNB VPB VPWR Y
.ends

* Black-box entry subcircuit for sky130_fd_sc_hd__and2b_4 abstract view
.subckt sky130_fd_sc_hd__and2b_4 A_N B VGND VNB VPB VPWR X
.ends

* Black-box entry subcircuit for sky130_fd_sc_hd__a31o_2 abstract view
.subckt sky130_fd_sc_hd__a31o_2 A1 A2 A3 B1 VGND VNB VPB VPWR X
.ends

* Black-box entry subcircuit for sky130_fd_sc_hd__or3_4 abstract view
.subckt sky130_fd_sc_hd__or3_4 A B C VGND VNB VPB VPWR X
.ends

* Black-box entry subcircuit for sky130_fd_sc_hd__and4_1 abstract view
.subckt sky130_fd_sc_hd__and4_1 A B C D VGND VNB VPB VPWR X
.ends

* Black-box entry subcircuit for sky130_fd_sc_hd__o21a_2 abstract view
.subckt sky130_fd_sc_hd__o21a_2 A1 A2 B1 VGND VNB VPB VPWR X
.ends

* Black-box entry subcircuit for sky130_fd_sc_hd__a21oi_4 abstract view
.subckt sky130_fd_sc_hd__a21oi_4 A1 A2 B1 VGND VNB VPB VPWR Y
.ends

* Black-box entry subcircuit for sky130_fd_sc_hd__or4bb_1 abstract view
.subckt sky130_fd_sc_hd__or4bb_1 A B C_N D_N VGND VNB VPB VPWR X
.ends

* Black-box entry subcircuit for sky130_fd_sc_hd__a32o_1 abstract view
.subckt sky130_fd_sc_hd__a32o_1 A1 A2 A3 B1 B2 VGND VNB VPB VPWR X
.ends

* Black-box entry subcircuit for sky130_fd_sc_hd__or4_2 abstract view
.subckt sky130_fd_sc_hd__or4_2 A B C D VGND VNB VPB VPWR X
.ends

* Black-box entry subcircuit for sky130_fd_sc_hd__a22oi_4 abstract view
.subckt sky130_fd_sc_hd__a22oi_4 A1 A2 B1 B2 VGND VNB VPB VPWR Y
.ends

* Black-box entry subcircuit for sky130_fd_sc_hd__or4_1 abstract view
.subckt sky130_fd_sc_hd__or4_1 A B C D VGND VNB VPB VPWR X
.ends

* Black-box entry subcircuit for sky130_fd_sc_hd__a2111o_1 abstract view
.subckt sky130_fd_sc_hd__a2111o_1 A1 A2 B1 C1 D1 VGND VNB VPB VPWR X
.ends

* Black-box entry subcircuit for sky130_fd_sc_hd__or4b_4 abstract view
.subckt sky130_fd_sc_hd__or4b_4 A B C D_N VGND VNB VPB VPWR X
.ends

.subckt tt_um_connerdaehler_boop VGND VPWR clk ena rst_n ui_in[0] ui_in[1] ui_in[2]
+ ui_in[3] ui_in[4] ui_in[5] ui_in[6] ui_in[7] uio_in[0] uio_in[1] uio_in[2] uio_in[3]
+ uio_in[4] uio_in[5] uio_in[6] uio_in[7] uio_oe[0] uio_oe[1] uio_oe[2] uio_oe[3]
+ uio_oe[4] uio_oe[5] uio_oe[6] uio_oe[7] uio_out[0] uio_out[1] uio_out[2] uio_out[3]
+ uio_out[4] uio_out[5] uio_out[6] uio_out[7] uo_out[0] uo_out[1] uo_out[2] uo_out[3]
+ uo_out[4] uo_out[5] uo_out[6] uo_out[7]
X_2106_ _2105_/B _2105_/C _2105_/A VGND VGND VPWR VPWR _2107_/B sky130_fd_sc_hd__o21ai_1
XFILLER_54_225 VGND VGND VPWR VPWR sky130_fd_sc_hd__fill_2
X_2037_ _2037_/A _2037_/B VGND VGND VPWR VPWR _2039_/B sky130_fd_sc_hd__xnor2_1
XFILLER_52_29 VGND VGND VPWR VPWR sky130_fd_sc_hd__fill_2
XFILLER_52_18 VGND VGND VPWR VPWR sky130_fd_sc_hd__decap_3
XFILLER_22_122 VGND VGND VPWR VPWR sky130_fd_sc_hd__decap_3
XFILLER_10_339 VGND VGND VPWR VPWR sky130_fd_sc_hd__fill_2
XTAP_TAPCELL_ROW_60_492 VGND VPWR sky130_fd_sc_hd__tapvpwrvgnd_1
XFILLER_45_225 VGND VGND VPWR VPWR sky130_fd_sc_hd__decap_3
XFILLER_45_203 VGND VGND VPWR VPWR sky130_fd_sc_hd__decap_3
XFILLER_45_247 VGND VGND VPWR VPWR sky130_fd_sc_hd__decap_3
XFILLER_60_228 VGND VGND VPWR VPWR sky130_fd_sc_hd__decap_3
XFILLER_60_206 VGND VGND VPWR VPWR sky130_fd_sc_hd__decap_3
XFILLER_13_111 VGND VGND VPWR VPWR sky130_fd_sc_hd__fill_1
XFILLER_42_62 VGND VGND VPWR VPWR sky130_fd_sc_hd__decap_3
XFILLER_5_354 VGND VGND VPWR VPWR sky130_fd_sc_hd__decap_3
XFILLER_54_9 VGND VGND VPWR VPWR sky130_fd_sc_hd__decap_3
XFILLER_3_12 VGND VGND VPWR VPWR sky130_fd_sc_hd__decap_3
XTAP_TAPCELL_ROW_8_181 VGND VPWR sky130_fd_sc_hd__tapvpwrvgnd_1
XFILLER_3_45 VGND VGND VPWR VPWR sky130_fd_sc_hd__decap_3
XFILLER_3_89 VGND VGND VPWR VPWR sky130_fd_sc_hd__decap_3
XFILLER_51_239 VGND VGND VPWR VPWR sky130_fd_sc_hd__decap_3
X_2724_ input6/X _2724_/B VGND VGND VPWR VPWR uo_out[7] sky130_fd_sc_hd__xnor2_4
X_2655_ _2657_/B _2649_/X _2653_/Y _2654_/X VGND VGND VPWR VPWR _2655_/X sky130_fd_sc_hd__o22a_1
XFILLER_8_192 VGND VGND VPWR VPWR sky130_fd_sc_hd__decap_3
X_1606_ _1606_/A _1606_/B VGND VGND VPWR VPWR _1607_/B sky130_fd_sc_hd__xnor2_1
X_2586_ _2541_/A _2552_/A _2538_/C VGND VGND VPWR VPWR _2587_/B sky130_fd_sc_hd__a21o_1
X_1537_ _1537_/A _1537_/B _1537_/C VGND VGND VPWR VPWR _1538_/B sky130_fd_sc_hd__and3_1
XFILLER_59_317 VGND VGND VPWR VPWR sky130_fd_sc_hd__decap_3
X_1468_ _1535_/A _1469_/B VGND VGND VPWR VPWR _1537_/B sky130_fd_sc_hd__nand2_1
XFILLER_47_18 VGND VGND VPWR VPWR sky130_fd_sc_hd__decap_3
X_1399_ _2767_/Q _1438_/B _1416_/D VGND VGND VPWR VPWR _1421_/A sky130_fd_sc_hd__or3_2
XFILLER_27_214 VGND VGND VPWR VPWR sky130_fd_sc_hd__decap_3
XFILLER_35_291 VGND VGND VPWR VPWR sky130_fd_sc_hd__fill_2
XFILLER_50_250 VGND VGND VPWR VPWR sky130_fd_sc_hd__fill_2
XFILLER_50_283 VGND VGND VPWR VPWR sky130_fd_sc_hd__decap_3
XFILLER_12_21 VGND VGND VPWR VPWR sky130_fd_sc_hd__decap_3
XFILLER_12_54 VGND VGND VPWR VPWR sky130_fd_sc_hd__fill_2
XFILLER_6_129 VGND VGND VPWR VPWR sky130_fd_sc_hd__decap_3
XFILLER_2_357 VGND VGND VPWR VPWR sky130_fd_sc_hd__fill_1
XTAP_TAPCELL_ROW_5_162 VGND VPWR sky130_fd_sc_hd__tapvpwrvgnd_1
XFILLER_18_203 VGND VGND VPWR VPWR sky130_fd_sc_hd__decap_3
XFILLER_37_73 VGND VGND VPWR VPWR sky130_fd_sc_hd__fill_1
XFILLER_18_247 VGND VGND VPWR VPWR sky130_fd_sc_hd__fill_1
XFILLER_37_95 VGND VGND VPWR VPWR sky130_fd_sc_hd__fill_2
XFILLER_18_269 VGND VGND VPWR VPWR sky130_fd_sc_hd__decap_3
XTAP_TAPCELL_ROW_28_297 VGND VPWR sky130_fd_sc_hd__tapvpwrvgnd_1
XFILLER_33_228 VGND VGND VPWR VPWR sky130_fd_sc_hd__decap_3
XFILLER_53_83 VGND VGND VPWR VPWR sky130_fd_sc_hd__decap_3
XFILLER_41_261 VGND VGND VPWR VPWR sky130_fd_sc_hd__decap_3
XTAP_TAPCELL_ROW_11_197 VGND VPWR sky130_fd_sc_hd__tapvpwrvgnd_1
X_2440_ _2440_/A _2440_/B VGND VGND VPWR VPWR _2441_/B sky130_fd_sc_hd__nand2_1
XFILLER_5_162 VGND VGND VPWR VPWR sky130_fd_sc_hd__decap_3
XFILLER_5_151 VGND VGND VPWR VPWR sky130_fd_sc_hd__decap_3
XFILLER_52_6 VGND VGND VPWR VPWR sky130_fd_sc_hd__decap_3
XFILLER_5_195 VGND VGND VPWR VPWR sky130_fd_sc_hd__decap_3
XFILLER_5_184 VGND VGND VPWR VPWR sky130_fd_sc_hd__fill_1
X_2371_ _2380_/A _2383_/A _2370_/X VGND VGND VPWR VPWR _2371_/X sky130_fd_sc_hd__a21o_1
XFILLER_56_309 VGND VGND VPWR VPWR sky130_fd_sc_hd__decap_3
XTAP_TAPCELL_ROW_19_242 VGND VPWR sky130_fd_sc_hd__tapvpwrvgnd_1
XFILLER_24_217 VGND VGND VPWR VPWR sky130_fd_sc_hd__decap_3
XFILLER_24_206 VGND VGND VPWR VPWR sky130_fd_sc_hd__decap_3
XFILLER_24_239 VGND VGND VPWR VPWR sky130_fd_sc_hd__decap_3
XFILLER_32_283 VGND VGND VPWR VPWR sky130_fd_sc_hd__decap_3
X_2707_ _2707_/A _2707_/B VGND VGND VPWR VPWR _2707_/Y sky130_fd_sc_hd__xnor2_1
X_2638_ _2660_/A _2638_/B _2638_/C VGND VGND VPWR VPWR _2640_/D sky130_fd_sc_hd__nor3_1
X_2569_ _2569_/A _2571_/A VGND VGND VPWR VPWR _2607_/A sky130_fd_sc_hd__xor2_1
XTAP_TAPCELL_ROW_2_143 VGND VPWR sky130_fd_sc_hd__tapvpwrvgnd_1
XFILLER_55_320 VGND VGND VPWR VPWR sky130_fd_sc_hd__decap_3
XFILLER_15_228 VGND VGND VPWR VPWR sky130_fd_sc_hd__decap_3
XTAP_TAPCELL_ROW_25_278 VGND VPWR sky130_fd_sc_hd__tapvpwrvgnd_1
XFILLER_23_20 VGND VGND VPWR VPWR sky130_fd_sc_hd__decap_3
XFILLER_23_75 VGND VGND VPWR VPWR sky130_fd_sc_hd__decap_3
XFILLER_2_165 VGND VGND VPWR VPWR sky130_fd_sc_hd__decap_3
XFILLER_48_61 VGND VGND VPWR VPWR sky130_fd_sc_hd__decap_3
XFILLER_0_24 VGND VGND VPWR VPWR sky130_fd_sc_hd__decap_3
XFILLER_0_35 VGND VGND VPWR VPWR sky130_fd_sc_hd__decap_3
XFILLER_58_180 VGND VGND VPWR VPWR sky130_fd_sc_hd__decap_3
XFILLER_46_331 VGND VGND VPWR VPWR sky130_fd_sc_hd__decap_3
XFILLER_0_57 VGND VGND VPWR VPWR sky130_fd_sc_hd__fill_1
XFILLER_0_79 VGND VGND VPWR VPWR sky130_fd_sc_hd__decap_3
X_1940_ _1940_/A _1940_/B VGND VGND VPWR VPWR _2016_/A sky130_fd_sc_hd__nor2_1
XFILLER_9_44 VGND VGND VPWR VPWR sky130_fd_sc_hd__decap_3
XFILLER_14_250 VGND VGND VPWR VPWR sky130_fd_sc_hd__fill_2
X_1871_ _1871_/A _1871_/B VGND VGND VPWR VPWR _1873_/B sky130_fd_sc_hd__and2_1
XFILLER_9_66 VGND VGND VPWR VPWR sky130_fd_sc_hd__fill_2
XFILLER_50_3 VGND VGND VPWR VPWR sky130_fd_sc_hd__decap_3
X_2423_ _2663_/A VGND VGND VPWR VPWR _2463_/A sky130_fd_sc_hd__inv_2
X_2354_ _2354_/A _2354_/B _2355_/B VGND VGND VPWR VPWR _2354_/X sky130_fd_sc_hd__or3b_1
X_2285_ _2286_/B _2310_/C _2293_/B VGND VGND VPWR VPWR _2309_/A sky130_fd_sc_hd__a21o_1
XFILLER_56_128 VGND VGND VPWR VPWR sky130_fd_sc_hd__decap_3
XFILLER_52_301 VGND VGND VPWR VPWR sky130_fd_sc_hd__decap_3
XFILLER_52_312 VGND VGND VPWR VPWR sky130_fd_sc_hd__decap_3
XFILLER_12_209 VGND VGND VPWR VPWR sky130_fd_sc_hd__decap_3
XFILLER_52_345 VGND VGND VPWR VPWR sky130_fd_sc_hd__decap_3
XFILLER_60_18 VGND VGND VPWR VPWR sky130_fd_sc_hd__decap_3
XFILLER_20_220 VGND VGND VPWR VPWR sky130_fd_sc_hd__decap_3
XFILLER_60_29 VGND VGND VPWR VPWR sky130_fd_sc_hd__decap_3
XFILLER_20_264 VGND VGND VPWR VPWR sky130_fd_sc_hd__decap_3
XFILLER_20_253 VGND VGND VPWR VPWR sky130_fd_sc_hd__fill_2
XPHY_EDGE_ROW_8_Left_69 VGND VGND VPWR VPWR sky130_fd_sc_hd__decap_3
XFILLER_28_342 VGND VGND VPWR VPWR sky130_fd_sc_hd__fill_2
XFILLER_18_64 VGND VGND VPWR VPWR sky130_fd_sc_hd__decap_3
XFILLER_43_334 VGND VGND VPWR VPWR sky130_fd_sc_hd__fill_2
XFILLER_43_312 VGND VGND VPWR VPWR sky130_fd_sc_hd__decap_3
XFILLER_34_52 VGND VGND VPWR VPWR sky130_fd_sc_hd__decap_3
XFILLER_11_220 VGND VGND VPWR VPWR sky130_fd_sc_hd__decap_3
XFILLER_11_231 VGND VGND VPWR VPWR sky130_fd_sc_hd__decap_3
XFILLER_34_85 VGND VGND VPWR VPWR sky130_fd_sc_hd__decap_3
XFILLER_11_264 VGND VGND VPWR VPWR sky130_fd_sc_hd__decap_3
XFILLER_11_275 VGND VGND VPWR VPWR sky130_fd_sc_hd__decap_3
XFILLER_11_286 VGND VGND VPWR VPWR sky130_fd_sc_hd__fill_2
XFILLER_7_257 VGND VGND VPWR VPWR sky130_fd_sc_hd__decap_3
XFILLER_50_40 VGND VGND VPWR VPWR sky130_fd_sc_hd__decap_3
XFILLER_59_60 VGND VGND VPWR VPWR sky130_fd_sc_hd__decap_3
XFILLER_59_93 VGND VGND VPWR VPWR sky130_fd_sc_hd__decap_3
XFILLER_38_106 VGND VGND VPWR VPWR sky130_fd_sc_hd__decap_3
X_2070_ _2065_/A _2065_/B _2063_/X VGND VGND VPWR VPWR _2138_/A sky130_fd_sc_hd__a21oi_1
XFILLER_19_320 VGND VGND VPWR VPWR sky130_fd_sc_hd__decap_3
XFILLER_15_6 VGND VGND VPWR VPWR sky130_fd_sc_hd__fill_2
XFILLER_46_150 VGND VGND VPWR VPWR sky130_fd_sc_hd__decap_3
XFILLER_34_312 VGND VGND VPWR VPWR sky130_fd_sc_hd__fill_1
XFILLER_34_356 VGND VGND VPWR VPWR sky130_fd_sc_hd__decap_3
X_1923_ _1557_/B _2054_/A _1922_/X VGND VGND VPWR VPWR _1926_/A sky130_fd_sc_hd__a21o_1
XTAP_TAPCELL_ROW_44_395 VGND VPWR sky130_fd_sc_hd__tapvpwrvgnd_1
X_1854_ _2000_/A _1854_/B VGND VGND VPWR VPWR _1856_/C sky130_fd_sc_hd__xnor2_1
X_1785_ _1787_/A _1787_/B _1784_/Y VGND VGND VPWR VPWR _1785_/X sky130_fd_sc_hd__o21ba_1
X_2406_ _2434_/B _2440_/A _2434_/A VGND VGND VPWR VPWR _2435_/A sky130_fd_sc_hd__a21oi_1
Xtt_um_connerdaehler_boop_54 VGND VGND VPWR VPWR tt_um_connerdaehler_boop_54/HI uio_oe[5]
+ sky130_fd_sc_hd__conb_1
X_2337_ _2217_/A _2347_/B _2346_/A _2336_/A _2770_/Q VGND VGND VPWR VPWR _2338_/C
+ sky130_fd_sc_hd__o2111a_1
XFILLER_29_106 VGND VGND VPWR VPWR sky130_fd_sc_hd__decap_3
X_2268_ _2269_/A _2269_/B VGND VGND VPWR VPWR _2268_/Y sky130_fd_sc_hd__nand2_1
XFILLER_29_128 VGND VGND VPWR VPWR sky130_fd_sc_hd__decap_3
XFILLER_55_18 VGND VGND VPWR VPWR sky130_fd_sc_hd__decap_3
X_2199_ _2735_/A _2199_/B VGND VGND VPWR VPWR _2199_/Y sky130_fd_sc_hd__nand2_1
XTAP_TAPCELL_ROW_35_340 VGND VPWR sky130_fd_sc_hd__tapvpwrvgnd_1
XFILLER_37_194 VGND VGND VPWR VPWR sky130_fd_sc_hd__decap_3
XFILLER_52_186 VGND VGND VPWR VPWR sky130_fd_sc_hd__decap_3
XFILLER_40_304 VGND VGND VPWR VPWR sky130_fd_sc_hd__decap_3
XFILLER_52_197 VGND VGND VPWR VPWR sky130_fd_sc_hd__decap_3
XFILLER_20_98 VGND VGND VPWR VPWR sky130_fd_sc_hd__decap_3
XFILLER_29_85 VGND VGND VPWR VPWR sky130_fd_sc_hd__decap_3
XFILLER_29_74 VGND VGND VPWR VPWR sky130_fd_sc_hd__fill_1
XFILLER_28_150 VGND VGND VPWR VPWR sky130_fd_sc_hd__decap_3
XTAP_TAPCELL_ROW_58_476 VGND VPWR sky130_fd_sc_hd__tapvpwrvgnd_1
XFILLER_28_183 VGND VGND VPWR VPWR sky130_fd_sc_hd__decap_3
XFILLER_16_301 VGND VGND VPWR VPWR sky130_fd_sc_hd__decap_3
XTAP_TAPCELL_ROW_41_376 VGND VPWR sky130_fd_sc_hd__tapvpwrvgnd_1
XFILLER_6_12 VGND VGND VPWR VPWR sky130_fd_sc_hd__decap_3
X_1570_ _1579_/A VGND VGND VPWR VPWR _1611_/A sky130_fd_sc_hd__inv_2
XFILLER_6_67 VGND VGND VPWR VPWR sky130_fd_sc_hd__decap_3
XFILLER_3_293 VGND VGND VPWR VPWR sky130_fd_sc_hd__decap_3
XFILLER_13_3 VGND VGND VPWR VPWR sky130_fd_sc_hd__decap_3
X_2122_ _1898_/A _2045_/B _1972_/B VGND VGND VPWR VPWR _2122_/Y sky130_fd_sc_hd__o21ai_1
XFILLER_26_109 VGND VGND VPWR VPWR sky130_fd_sc_hd__decap_3
X_2053_ _2051_/A _2051_/B _2114_/A VGND VGND VPWR VPWR _2056_/A sky130_fd_sc_hd__o21ba_1
XFILLER_34_164 VGND VGND VPWR VPWR sky130_fd_sc_hd__fill_1
XTAP_TAPCELL_ROW_32_321 VGND VPWR sky130_fd_sc_hd__tapvpwrvgnd_1
XFILLER_22_326 VGND VGND VPWR VPWR sky130_fd_sc_hd__fill_2
X_1906_ _1890_/A _1890_/B _1891_/Y VGND VGND VPWR VPWR _1909_/A sky130_fd_sc_hd__a21bo_1
X_1837_ _1837_/A _1837_/B VGND VGND VPWR VPWR _1935_/A sky130_fd_sc_hd__xnor2_1
X_1768_ _1751_/Y _1760_/Y _1782_/A _1767_/X VGND VGND VPWR VPWR _1780_/A sky130_fd_sc_hd__a31oi_1
X_1699_ _1836_/A _1836_/B VGND VGND VPWR VPWR _1699_/Y sky130_fd_sc_hd__nand2b_1
XFILLER_1_219 VGND VGND VPWR VPWR sky130_fd_sc_hd__decap_3
XFILLER_57_267 VGND VGND VPWR VPWR sky130_fd_sc_hd__decap_3
XFILLER_25_131 VGND VGND VPWR VPWR sky130_fd_sc_hd__decap_3
XFILLER_15_21 VGND VGND VPWR VPWR sky130_fd_sc_hd__decap_3
XFILLER_13_337 VGND VGND VPWR VPWR sky130_fd_sc_hd__decap_3
XFILLER_40_134 VGND VGND VPWR VPWR sky130_fd_sc_hd__fill_1
XFILLER_40_178 VGND VGND VPWR VPWR sky130_fd_sc_hd__decap_3
XFILLER_31_53 VGND VGND VPWR VPWR sky130_fd_sc_hd__decap_3
XFILLER_31_75 VGND VGND VPWR VPWR sky130_fd_sc_hd__decap_3
XFILLER_48_278 VGND VGND VPWR VPWR sky130_fd_sc_hd__decap_3
XFILLER_48_256 VGND VGND VPWR VPWR sky130_fd_sc_hd__decap_3
XFILLER_16_164 VGND VGND VPWR VPWR sky130_fd_sc_hd__fill_1
XFILLER_31_156 VGND VGND VPWR VPWR sky130_fd_sc_hd__decap_3
X_2740_ _2740_/A _2742_/B VGND VGND VPWR VPWR _2765_/D sky130_fd_sc_hd__nor2_1
XFILLER_31_189 VGND VGND VPWR VPWR sky130_fd_sc_hd__decap_3
X_2671_ _1489_/B _2662_/B _2662_/C _2668_/Y _2670_/X VGND VGND VPWR VPWR _2672_/C
+ sky130_fd_sc_hd__a311oi_1
XFILLER_8_352 VGND VGND VPWR VPWR sky130_fd_sc_hd__decap_3
X_1622_ _1622_/A _1622_/B VGND VGND VPWR VPWR _1627_/A sky130_fd_sc_hd__xnor2_1
X_1553_ _1813_/A _1553_/B VGND VGND VPWR VPWR _1568_/B sky130_fd_sc_hd__xor2_1
X_1484_ _1484_/A _1484_/B VGND VGND VPWR VPWR _1488_/B sky130_fd_sc_hd__xor2_1
XFILLER_39_234 VGND VGND VPWR VPWR sky130_fd_sc_hd__decap_3
XFILLER_39_212 VGND VGND VPWR VPWR sky130_fd_sc_hd__fill_2
X_2105_ _2105_/A _2105_/B _2105_/C VGND VGND VPWR VPWR _2126_/B sky130_fd_sc_hd__or3_1
XFILLER_54_204 VGND VGND VPWR VPWR sky130_fd_sc_hd__decap_3
XFILLER_39_278 VGND VGND VPWR VPWR sky130_fd_sc_hd__fill_2
X_2036_ _1656_/A _1582_/A _2146_/A _2021_/Y VGND VGND VPWR VPWR _2039_/A sky130_fd_sc_hd__o31a_1
XFILLER_54_237 VGND VGND VPWR VPWR sky130_fd_sc_hd__decap_3
XFILLER_22_134 VGND VGND VPWR VPWR sky130_fd_sc_hd__decap_3
XFILLER_22_112 VGND VGND VPWR VPWR sky130_fd_sc_hd__fill_2
XFILLER_22_101 VGND VGND VPWR VPWR sky130_fd_sc_hd__decap_3
XFILLER_10_329 VGND VGND VPWR VPWR sky130_fd_sc_hd__fill_2
XTAP_TAPCELL_ROW_60_493 VGND VPWR sky130_fd_sc_hd__tapvpwrvgnd_1
XFILLER_45_215 VGND VGND VPWR VPWR sky130_fd_sc_hd__decap_3
XPHY_EDGE_ROW_37_Left_98 VGND VGND VPWR VPWR sky130_fd_sc_hd__decap_3
XFILLER_60_218 VGND VGND VPWR VPWR sky130_fd_sc_hd__decap_3
XFILLER_53_281 VGND VGND VPWR VPWR sky130_fd_sc_hd__decap_3
XFILLER_53_270 VGND VGND VPWR VPWR sky130_fd_sc_hd__decap_3
XFILLER_26_97 VGND VGND VPWR VPWR sky130_fd_sc_hd__decap_3
XFILLER_13_189 VGND VGND VPWR VPWR sky130_fd_sc_hd__decap_3
XFILLER_42_52 VGND VGND VPWR VPWR sky130_fd_sc_hd__decap_3
XFILLER_42_85 VGND VGND VPWR VPWR sky130_fd_sc_hd__decap_3
XPHY_EDGE_ROW_39_Left_100 VGND VGND VPWR VPWR sky130_fd_sc_hd__decap_3
XFILLER_5_322 VGND VGND VPWR VPWR sky130_fd_sc_hd__decap_3
XFILLER_47_9 VGND VGND VPWR VPWR sky130_fd_sc_hd__decap_3
XFILLER_3_24 VGND VGND VPWR VPWR sky130_fd_sc_hd__decap_3
XFILLER_3_68 VGND VGND VPWR VPWR sky130_fd_sc_hd__decap_3
XFILLER_3_57 VGND VGND VPWR VPWR sky130_fd_sc_hd__decap_3
Xwire19 wire19/A VGND VGND VPWR VPWR wire19/X sky130_fd_sc_hd__buf_1
XFILLER_36_259 VGND VGND VPWR VPWR sky130_fd_sc_hd__decap_3
XFILLER_36_237 VGND VGND VPWR VPWR sky130_fd_sc_hd__decap_3
XFILLER_44_270 VGND VGND VPWR VPWR sky130_fd_sc_hd__decap_3
X_2723_ _2468_/X _2672_/X _2720_/X _2722_/Y VGND VGND VPWR VPWR _2724_/B sky130_fd_sc_hd__o2bb2a_2
XFILLER_8_171 VGND VGND VPWR VPWR sky130_fd_sc_hd__decap_3
X_2654_ _2419_/Y _2652_/X _2653_/C _2669_/A VGND VGND VPWR VPWR _2654_/X sky130_fd_sc_hd__o2bb2a_1
X_1605_ _1631_/A _1631_/B _1604_/A VGND VGND VPWR VPWR _1607_/A sky130_fd_sc_hd__o21bai_2
X_2585_ _2628_/A _2584_/B _2542_/Y VGND VGND VPWR VPWR _2634_/A sky130_fd_sc_hd__a21o_1
X_1536_ _1537_/A _1537_/B _1537_/C VGND VGND VPWR VPWR _1538_/A sky130_fd_sc_hd__a21oi_1
X_1467_ _1972_/A _1467_/B VGND VGND VPWR VPWR _1469_/B sky130_fd_sc_hd__xnor2_1
XFILLER_59_329 VGND VGND VPWR VPWR sky130_fd_sc_hd__decap_3
X_1398_ _2767_/Q _1438_/B _1416_/D VGND VGND VPWR VPWR _1398_/Y sky130_fd_sc_hd__nor3_2
XFILLER_42_207 VGND VGND VPWR VPWR sky130_fd_sc_hd__decap_3
X_2019_ _1656_/A _1582_/A _2146_/A _1947_/B _1597_/Y VGND VGND VPWR VPWR _2022_/A
+ sky130_fd_sc_hd__o32a_1
XFILLER_35_281 VGND VGND VPWR VPWR sky130_fd_sc_hd__fill_2
XFILLER_10_104 VGND VGND VPWR VPWR sky130_fd_sc_hd__decap_3
XFILLER_10_137 VGND VGND VPWR VPWR sky130_fd_sc_hd__decap_3
XFILLER_6_108 VGND VGND VPWR VPWR sky130_fd_sc_hd__decap_3
XFILLER_50_295 VGND VGND VPWR VPWR sky130_fd_sc_hd__decap_3
XFILLER_12_88 VGND VGND VPWR VPWR sky130_fd_sc_hd__decap_3
XTAP_TAPCELL_ROW_5_163 VGND VPWR sky130_fd_sc_hd__tapvpwrvgnd_1
XFILLER_58_351 VGND VGND VPWR VPWR sky130_fd_sc_hd__decap_3
XFILLER_37_52 VGND VGND VPWR VPWR sky130_fd_sc_hd__decap_3
XTAP_TAPCELL_ROW_28_298 VGND VPWR sky130_fd_sc_hd__tapvpwrvgnd_1
XFILLER_26_281 VGND VGND VPWR VPWR sky130_fd_sc_hd__fill_1
XFILLER_41_240 VGND VGND VPWR VPWR sky130_fd_sc_hd__decap_3
XFILLER_53_95 VGND VGND VPWR VPWR sky130_fd_sc_hd__decap_3
XFILLER_41_273 VGND VGND VPWR VPWR sky130_fd_sc_hd__decap_3
XTAP_TAPCELL_ROW_11_198 VGND VPWR sky130_fd_sc_hd__tapvpwrvgnd_1
XFILLER_45_6 VGND VGND VPWR VPWR sky130_fd_sc_hd__decap_3
X_2370_ _2079_/A _2379_/A _2079_/B VGND VGND VPWR VPWR _2370_/X sky130_fd_sc_hd__o21ba_1
XFILLER_49_340 VGND VGND VPWR VPWR sky130_fd_sc_hd__decap_3
XTAP_TAPCELL_ROW_19_243 VGND VPWR sky130_fd_sc_hd__tapvpwrvgnd_1
XFILLER_17_281 VGND VGND VPWR VPWR sky130_fd_sc_hd__decap_3
XFILLER_32_240 VGND VGND VPWR VPWR sky130_fd_sc_hd__decap_3
XFILLER_32_262 VGND VGND VPWR VPWR sky130_fd_sc_hd__decap_3
X_2706_ _2707_/A _2707_/B VGND VGND VPWR VPWR _2706_/X sky130_fd_sc_hd__and2b_1
X_2637_ _2637_/A _2637_/B VGND VGND VPWR VPWR _2638_/C sky130_fd_sc_hd__xnor2_1
XPHY_EDGE_ROW_12_Right_12 VGND VGND VPWR VPWR sky130_fd_sc_hd__decap_3
X_2568_ _2569_/A _2571_/A VGND VGND VPWR VPWR _2568_/X sky130_fd_sc_hd__and2_1
XFILLER_58_29 VGND VGND VPWR VPWR sky130_fd_sc_hd__decap_3
XFILLER_58_18 VGND VGND VPWR VPWR sky130_fd_sc_hd__decap_3
X_1519_ _2000_/A _1717_/B VGND VGND VPWR VPWR _1718_/A sky130_fd_sc_hd__and2_1
X_2499_ _2496_/B _2525_/B _2497_/Y VGND VGND VPWR VPWR _2522_/A sky130_fd_sc_hd__a21oi_2
XTAP_TAPCELL_ROW_2_144 VGND VPWR sky130_fd_sc_hd__tapvpwrvgnd_1
XFILLER_55_343 VGND VGND VPWR VPWR sky130_fd_sc_hd__decap_3
XFILLER_55_332 VGND VGND VPWR VPWR sky130_fd_sc_hd__decap_3
XPHY_EDGE_ROW_21_Right_21 VGND VGND VPWR VPWR sky130_fd_sc_hd__decap_3
XTAP_TAPCELL_ROW_25_279 VGND VPWR sky130_fd_sc_hd__tapvpwrvgnd_1
XFILLER_23_32 VGND VGND VPWR VPWR sky130_fd_sc_hd__decap_3
XFILLER_23_284 VGND VGND VPWR VPWR sky130_fd_sc_hd__fill_1
XPHY_EDGE_ROW_30_Right_30 VGND VGND VPWR VPWR sky130_fd_sc_hd__decap_3
XFILLER_46_343 VGND VGND VPWR VPWR sky130_fd_sc_hd__decap_3
XFILLER_0_47 VGND VGND VPWR VPWR sky130_fd_sc_hd__decap_3
XTAP_TAPCELL_ROW_16_224 VGND VPWR sky130_fd_sc_hd__tapvpwrvgnd_1
XFILLER_9_12 VGND VGND VPWR VPWR sky130_fd_sc_hd__decap_3
XFILLER_14_262 VGND VGND VPWR VPWR sky130_fd_sc_hd__decap_3
X_1870_ _1870_/A _1870_/B VGND VGND VPWR VPWR _1871_/B sky130_fd_sc_hd__nand2_1
XFILLER_14_284 VGND VGND VPWR VPWR sky130_fd_sc_hd__decap_3
XPHY_EDGE_ROW_24_Left_85 VGND VGND VPWR VPWR sky130_fd_sc_hd__decap_3
X_2422_ _2506_/A _2506_/B VGND VGND VPWR VPWR _2663_/A sky130_fd_sc_hd__xor2_4
XFILLER_43_3 VGND VGND VPWR VPWR sky130_fd_sc_hd__decap_3
X_2353_ _2346_/X _2356_/C _2351_/X _2352_/Y VGND VGND VPWR VPWR _2355_/B sky130_fd_sc_hd__a211oi_1
X_2284_ _2284_/A _2310_/C VGND VGND VPWR VPWR _2293_/B sky130_fd_sc_hd__nor2_1
XFILLER_56_107 VGND VGND VPWR VPWR sky130_fd_sc_hd__decap_3
XFILLER_37_321 VGND VGND VPWR VPWR sky130_fd_sc_hd__decap_3
XFILLER_37_343 VGND VGND VPWR VPWR sky130_fd_sc_hd__decap_3
XFILLER_52_324 VGND VGND VPWR VPWR sky130_fd_sc_hd__decap_3
XFILLER_52_357 VGND VGND VPWR VPWR sky130_fd_sc_hd__decap_3
XFILLER_20_243 VGND VGND VPWR VPWR sky130_fd_sc_hd__decap_3
X_1999_ _1999_/A _2003_/A _2356_/B VGND VGND VPWR VPWR _2144_/A sky130_fd_sc_hd__or3_2
XFILLER_20_298 VGND VGND VPWR VPWR sky130_fd_sc_hd__decap_3
XFILLER_18_21 VGND VGND VPWR VPWR sky130_fd_sc_hd__fill_2
XTAP_TAPCELL_ROW_38_360 VGND VPWR sky130_fd_sc_hd__tapvpwrvgnd_1
XFILLER_55_184 VGND VGND VPWR VPWR sky130_fd_sc_hd__decap_3
XFILLER_43_324 VGND VGND VPWR VPWR sky130_fd_sc_hd__fill_1
XFILLER_43_357 VGND VGND VPWR VPWR sky130_fd_sc_hd__decap_3
XFILLER_34_42 VGND VGND VPWR VPWR sky130_fd_sc_hd__decap_3
XFILLER_34_75 VGND VGND VPWR VPWR sky130_fd_sc_hd__decap_3
XFILLER_11_243 VGND VGND VPWR VPWR sky130_fd_sc_hd__decap_3
XFILLER_7_203 VGND VGND VPWR VPWR sky130_fd_sc_hd__decap_3
XFILLER_7_225 VGND VGND VPWR VPWR sky130_fd_sc_hd__decap_3
XFILLER_50_85 VGND VGND VPWR VPWR sky130_fd_sc_hd__decap_3
XFILLER_50_74 VGND VGND VPWR VPWR sky130_fd_sc_hd__fill_1
XFILLER_50_52 VGND VGND VPWR VPWR sky130_fd_sc_hd__fill_2
XFILLER_59_72 VGND VGND VPWR VPWR sky130_fd_sc_hd__decap_3
XFILLER_38_118 VGND VGND VPWR VPWR sky130_fd_sc_hd__decap_3
XFILLER_34_324 VGND VGND VPWR VPWR sky130_fd_sc_hd__fill_1
X_1922_ _1968_/A _1968_/B VGND VGND VPWR VPWR _1922_/X sky130_fd_sc_hd__and2_1
XTAP_TAPCELL_ROW_44_396 VGND VPWR sky130_fd_sc_hd__tapvpwrvgnd_1
X_1853_ _2000_/A _1929_/B _1852_/A VGND VGND VPWR VPWR _1859_/A sky130_fd_sc_hd__a21bo_1
X_1784_ _1784_/A _1784_/B VGND VGND VPWR VPWR _1784_/Y sky130_fd_sc_hd__nand2_1
XFILLER_6_291 VGND VGND VPWR VPWR sky130_fd_sc_hd__fill_1
X_2405_ _2439_/A _2444_/A VGND VGND VPWR VPWR _2440_/A sky130_fd_sc_hd__nand2_1
Xtt_um_connerdaehler_boop_55 VGND VGND VPWR VPWR tt_um_connerdaehler_boop_55/HI uio_oe[6]
+ sky130_fd_sc_hd__conb_1
X_2336_ _2336_/A _2336_/B _2347_/B VGND VGND VPWR VPWR _2348_/A sky130_fd_sc_hd__and3_1
X_2267_ _2267_/A _2267_/B VGND VGND VPWR VPWR _2269_/B sky130_fd_sc_hd__xnor2_2
X_2198_ _2735_/A _2201_/B VGND VGND VPWR VPWR _2250_/A sky130_fd_sc_hd__nand2_1
XFILLER_52_110 VGND VGND VPWR VPWR sky130_fd_sc_hd__decap_3
XFILLER_25_302 VGND VGND VPWR VPWR sky130_fd_sc_hd__decap_3
XFILLER_1_90 VGND VGND VPWR VPWR sky130_fd_sc_hd__fill_2
XFILLER_25_335 VGND VGND VPWR VPWR sky130_fd_sc_hd__fill_1
XTAP_TAPCELL_ROW_35_341 VGND VPWR sky130_fd_sc_hd__tapvpwrvgnd_1
XFILLER_52_165 VGND VGND VPWR VPWR sky130_fd_sc_hd__decap_3
XFILLER_4_206 VGND VGND VPWR VPWR sky130_fd_sc_hd__decap_3
XFILLER_29_42 VGND VGND VPWR VPWR sky130_fd_sc_hd__decap_3
XFILLER_29_97 VGND VGND VPWR VPWR sky130_fd_sc_hd__decap_3
XTAP_TAPCELL_ROW_58_477 VGND VPWR sky130_fd_sc_hd__tapvpwrvgnd_1
XFILLER_45_30 VGND VGND VPWR VPWR sky130_fd_sc_hd__decap_3
XFILLER_45_52 VGND VGND VPWR VPWR sky130_fd_sc_hd__decap_3
XFILLER_43_121 VGND VGND VPWR VPWR sky130_fd_sc_hd__decap_3
XFILLER_28_195 VGND VGND VPWR VPWR sky130_fd_sc_hd__fill_1
XFILLER_43_154 VGND VGND VPWR VPWR sky130_fd_sc_hd__decap_3
XTAP_TAPCELL_ROW_41_377 VGND VPWR sky130_fd_sc_hd__tapvpwrvgnd_1
XFILLER_6_24 VGND VGND VPWR VPWR sky130_fd_sc_hd__decap_3
XFILLER_3_261 VGND VGND VPWR VPWR sky130_fd_sc_hd__decap_3
X_2121_ _2121_/A _2121_/B VGND VGND VPWR VPWR _2177_/A sky130_fd_sc_hd__xnor2_1
XTAP_TAPCELL_ROW_49_422 VGND VPWR sky130_fd_sc_hd__tapvpwrvgnd_1
X_2052_ _2264_/A _2113_/B VGND VGND VPWR VPWR _2114_/A sky130_fd_sc_hd__nor2_1
XFILLER_34_154 VGND VGND VPWR VPWR sky130_fd_sc_hd__fill_1
XTAP_TAPCELL_ROW_32_322 VGND VPWR sky130_fd_sc_hd__tapvpwrvgnd_1
XFILLER_34_187 VGND VGND VPWR VPWR sky130_fd_sc_hd__decap_3
XFILLER_22_338 VGND VGND VPWR VPWR sky130_fd_sc_hd__fill_1
X_1905_ _1902_/A _1902_/B _1904_/Y VGND VGND VPWR VPWR _1910_/A sky130_fd_sc_hd__o21ai_1
X_1836_ _1836_/A _1836_/B VGND VGND VPWR VPWR _1837_/B sky130_fd_sc_hd__xnor2_1
XPHY_EDGE_ROW_6_Right_6 VGND VGND VPWR VPWR sky130_fd_sc_hd__decap_3
X_1767_ _1775_/A _1764_/B _1763_/A VGND VGND VPWR VPWR _1767_/X sky130_fd_sc_hd__o21a_1
X_1698_ _1698_/A _1698_/B VGND VGND VPWR VPWR _1836_/B sky130_fd_sc_hd__xnor2_1
X_2319_ _2311_/Y _2317_/Y _2318_/Y _2298_/A VGND VGND VPWR VPWR _2321_/B sky130_fd_sc_hd__a211oi_2
XFILLER_57_246 VGND VGND VPWR VPWR sky130_fd_sc_hd__decap_3
XFILLER_57_279 VGND VGND VPWR VPWR sky130_fd_sc_hd__fill_1
XTAP_TAPCELL_ROW_55_458 VGND VPWR sky130_fd_sc_hd__tapvpwrvgnd_1
XPHY_EDGE_ROW_11_Left_72 VGND VGND VPWR VPWR sky130_fd_sc_hd__decap_3
XFILLER_25_143 VGND VGND VPWR VPWR sky130_fd_sc_hd__decap_3
XFILLER_13_327 VGND VGND VPWR VPWR sky130_fd_sc_hd__decap_3
XFILLER_13_349 VGND VGND VPWR VPWR sky130_fd_sc_hd__decap_3
XFILLER_40_113 VGND VGND VPWR VPWR sky130_fd_sc_hd__decap_3
XFILLER_40_157 VGND VGND VPWR VPWR sky130_fd_sc_hd__decap_3
XFILLER_15_88 VGND VGND VPWR VPWR sky130_fd_sc_hd__decap_3
XFILLER_31_87 VGND VGND VPWR VPWR sky130_fd_sc_hd__fill_1
XFILLER_0_220 VGND VGND VPWR VPWR sky130_fd_sc_hd__decap_3
XFILLER_31_135 VGND VGND VPWR VPWR sky130_fd_sc_hd__decap_3
XPHY_EDGE_ROW_59_Right_59 VGND VGND VPWR VPWR sky130_fd_sc_hd__decap_3
X_2670_ _2662_/A _2662_/B _2657_/B _2665_/B VGND VGND VPWR VPWR _2670_/X sky130_fd_sc_hd__a31o_1
XFILLER_8_331 VGND VGND VPWR VPWR sky130_fd_sc_hd__decap_3
X_1621_ _1787_/B _1650_/B VGND VGND VPWR VPWR _1651_/A sky130_fd_sc_hd__nor2_1
X_1552_ _1586_/A _1669_/B _1572_/B VGND VGND VPWR VPWR _1553_/B sky130_fd_sc_hd__a21bo_1
X_1483_ _1484_/A _1483_/B _1483_/C VGND VGND VPWR VPWR _1521_/A sky130_fd_sc_hd__and3_1
X_2104_ _2104_/A _2104_/B _2104_/C VGND VGND VPWR VPWR _2105_/C sky130_fd_sc_hd__nor3_1
XFILLER_39_257 VGND VGND VPWR VPWR sky130_fd_sc_hd__decap_3
XFILLER_54_216 VGND VGND VPWR VPWR sky130_fd_sc_hd__decap_3
X_2035_ _2102_/A _2102_/B VGND VGND VPWR VPWR _2040_/A sky130_fd_sc_hd__and2_1
XTAP_TAPCELL_ROW_60_494 VGND VPWR sky130_fd_sc_hd__tapvpwrvgnd_1
X_1819_ _1819_/A _1819_/B _1819_/C VGND VGND VPWR VPWR _1834_/B sky130_fd_sc_hd__nor3_1
XFILLER_7_9 VGND VGND VPWR VPWR sky130_fd_sc_hd__decap_3
XFILLER_45_238 VGND VGND VPWR VPWR sky130_fd_sc_hd__decap_3
XFILLER_26_65 VGND VGND VPWR VPWR sky130_fd_sc_hd__decap_3
XFILLER_13_102 VGND VGND VPWR VPWR sky130_fd_sc_hd__decap_3
XFILLER_53_293 VGND VGND VPWR VPWR sky130_fd_sc_hd__decap_3
XFILLER_26_76 VGND VGND VPWR VPWR sky130_fd_sc_hd__fill_1
XFILLER_13_146 VGND VGND VPWR VPWR sky130_fd_sc_hd__decap_3
XFILLER_42_42 VGND VGND VPWR VPWR sky130_fd_sc_hd__decap_3
XFILLER_21_190 VGND VGND VPWR VPWR sky130_fd_sc_hd__decap_3
XFILLER_5_312 VGND VGND VPWR VPWR sky130_fd_sc_hd__decap_3
XFILLER_42_97 VGND VGND VPWR VPWR sky130_fd_sc_hd__fill_2
XFILLER_5_334 VGND VGND VPWR VPWR sky130_fd_sc_hd__fill_2
XFILLER_3_36 VGND VGND VPWR VPWR sky130_fd_sc_hd__decap_3
XFILLER_36_205 VGND VGND VPWR VPWR sky130_fd_sc_hd__decap_3
XFILLER_29_290 VGND VGND VPWR VPWR sky130_fd_sc_hd__fill_1
XFILLER_44_282 VGND VGND VPWR VPWR sky130_fd_sc_hd__decap_3
X_2722_ _2669_/A _2721_/Y _2468_/X VGND VGND VPWR VPWR _2722_/Y sky130_fd_sc_hd__o21ai_1
X_2653_ _2669_/A _2653_/B _2653_/C VGND VGND VPWR VPWR _2653_/Y sky130_fd_sc_hd__nor3_1
XFILLER_8_183 VGND VGND VPWR VPWR sky130_fd_sc_hd__decap_3
X_1604_ _1604_/A _1604_/B VGND VGND VPWR VPWR _1631_/B sky130_fd_sc_hd__xnor2_1
X_2584_ _2542_/Y _2584_/B VGND VGND VPWR VPWR _2628_/B sky130_fd_sc_hd__nand2b_1
X_1535_ _1535_/A _1535_/B VGND VGND VPWR VPWR _1537_/C sky130_fd_sc_hd__xor2_1
XFILLER_59_308 VGND VGND VPWR VPWR sky130_fd_sc_hd__decap_3
X_1466_ _1899_/A _1467_/B VGND VGND VPWR VPWR _1537_/A sky130_fd_sc_hd__nand2_1
X_1397_ _2764_/Q _2765_/Q _2742_/A VGND VGND VPWR VPWR _1416_/D sky130_fd_sc_hd__and3_2
XFILLER_27_205 VGND VGND VPWR VPWR sky130_fd_sc_hd__decap_3
X_2018_ _2742_/A _2335_/B VGND VGND VPWR VPWR _2146_/A sky130_fd_sc_hd__nand2_1
XFILLER_35_271 VGND VGND VPWR VPWR sky130_fd_sc_hd__decap_3
XFILLER_10_116 VGND VGND VPWR VPWR sky130_fd_sc_hd__fill_1
XFILLER_50_274 VGND VGND VPWR VPWR sky130_fd_sc_hd__decap_3
XFILLER_12_12 VGND VGND VPWR VPWR sky130_fd_sc_hd__decap_3
XFILLER_12_34 VGND VGND VPWR VPWR sky130_fd_sc_hd__decap_3
XFILLER_12_67 VGND VGND VPWR VPWR sky130_fd_sc_hd__decap_3
XFILLER_2_304 VGND VGND VPWR VPWR sky130_fd_sc_hd__decap_3
XFILLER_5_6 VGND VGND VPWR VPWR sky130_fd_sc_hd__decap_3
XFILLER_2_348 VGND VGND VPWR VPWR sky130_fd_sc_hd__decap_3
XFILLER_2_315 VGND VGND VPWR VPWR sky130_fd_sc_hd__decap_3
XFILLER_58_330 VGND VGND VPWR VPWR sky130_fd_sc_hd__decap_3
XFILLER_37_42 VGND VGND VPWR VPWR sky130_fd_sc_hd__decap_3
XFILLER_37_64 VGND VGND VPWR VPWR sky130_fd_sc_hd__decap_3
XFILLER_18_238 VGND VGND VPWR VPWR sky130_fd_sc_hd__decap_3
XFILLER_37_86 VGND VGND VPWR VPWR sky130_fd_sc_hd__decap_3
XTAP_TAPCELL_ROW_28_299 VGND VPWR sky130_fd_sc_hd__tapvpwrvgnd_1
XFILLER_53_52 VGND VGND VPWR VPWR sky130_fd_sc_hd__decap_3
XFILLER_53_30 VGND VGND VPWR VPWR sky130_fd_sc_hd__decap_3
XFILLER_53_74 VGND VGND VPWR VPWR sky130_fd_sc_hd__fill_2
XFILLER_41_252 VGND VGND VPWR VPWR sky130_fd_sc_hd__decap_3
XTAP_TAPCELL_ROW_11_199 VGND VPWR sky130_fd_sc_hd__tapvpwrvgnd_1
XFILLER_5_175 VGND VGND VPWR VPWR sky130_fd_sc_hd__decap_3
XFILLER_38_6 VGND VGND VPWR VPWR sky130_fd_sc_hd__decap_3
XFILLER_49_352 VGND VGND VPWR VPWR sky130_fd_sc_hd__decap_3
XTAP_TAPCELL_ROW_19_244 VGND VPWR sky130_fd_sc_hd__tapvpwrvgnd_1
XFILLER_17_260 VGND VGND VPWR VPWR sky130_fd_sc_hd__decap_3
XFILLER_17_293 VGND VGND VPWR VPWR sky130_fd_sc_hd__fill_2
X_2705_ input6/X _2705_/B VGND VGND VPWR VPWR uo_out[4] sky130_fd_sc_hd__xnor2_4
X_2636_ _2636_/A _2636_/B VGND VGND VPWR VPWR _2637_/B sky130_fd_sc_hd__nor2_1
X_2567_ _2570_/A _2570_/B VGND VGND VPWR VPWR _2571_/A sky130_fd_sc_hd__nor2_1
X_1518_ _1518_/A _1518_/B VGND VGND VPWR VPWR _1717_/B sky130_fd_sc_hd__xnor2_1
X_2498_ _2498_/A _2653_/B VGND VGND VPWR VPWR _2525_/B sky130_fd_sc_hd__xnor2_2
XPHY_EDGE_ROW_58_Left_119 VGND VGND VPWR VPWR sky130_fd_sc_hd__decap_3
X_1449_ _2777_/Q _1456_/B VGND VGND VPWR VPWR _1534_/A sky130_fd_sc_hd__nor2_1
XTAP_TAPCELL_ROW_2_145 VGND VPWR sky130_fd_sc_hd__tapvpwrvgnd_1
XFILLER_55_311 VGND VGND VPWR VPWR sky130_fd_sc_hd__decap_3
XFILLER_55_355 VGND VGND VPWR VPWR sky130_fd_sc_hd__decap_3
XFILLER_23_241 VGND VGND VPWR VPWR sky130_fd_sc_hd__fill_1
XFILLER_23_274 VGND VGND VPWR VPWR sky130_fd_sc_hd__decap_3
XFILLER_23_11 VGND VGND VPWR VPWR sky130_fd_sc_hd__decap_3
XFILLER_23_55 VGND VGND VPWR VPWR sky130_fd_sc_hd__fill_1
XFILLER_23_66 VGND VGND VPWR VPWR sky130_fd_sc_hd__decap_3
XFILLER_23_99 VGND VGND VPWR VPWR sky130_fd_sc_hd__decap_3
XFILLER_3_3 VGND VGND VPWR VPWR sky130_fd_sc_hd__decap_3
XFILLER_2_156 VGND VGND VPWR VPWR sky130_fd_sc_hd__decap_3
XFILLER_48_52 VGND VGND VPWR VPWR sky130_fd_sc_hd__decap_3
XFILLER_48_41 VGND VGND VPWR VPWR sky130_fd_sc_hd__fill_1
XFILLER_0_15 VGND VGND VPWR VPWR sky130_fd_sc_hd__decap_3
XFILLER_58_171 VGND VGND VPWR VPWR sky130_fd_sc_hd__decap_3
XFILLER_46_355 VGND VGND VPWR VPWR sky130_fd_sc_hd__decap_3
XTAP_TAPCELL_ROW_16_225 VGND VPWR sky130_fd_sc_hd__tapvpwrvgnd_1
XFILLER_14_274 VGND VGND VPWR VPWR sky130_fd_sc_hd__decap_3
XFILLER_9_57 VGND VGND VPWR VPWR sky130_fd_sc_hd__decap_3
XFILLER_14_296 VGND VGND VPWR VPWR sky130_fd_sc_hd__fill_2
X_2421_ _2460_/A _2653_/B _2512_/B VGND VGND VPWR VPWR _2426_/A sky130_fd_sc_hd__a21oi_1
X_2352_ _2336_/A _2356_/B _2346_/X VGND VGND VPWR VPWR _2352_/Y sky130_fd_sc_hd__a21oi_1
XFILLER_36_3 VGND VGND VPWR VPWR sky130_fd_sc_hd__decap_3
X_2283_ _2283_/A _2283_/B VGND VGND VPWR VPWR _2310_/C sky130_fd_sc_hd__or2_1
XFILLER_56_119 VGND VGND VPWR VPWR sky130_fd_sc_hd__decap_3
XFILLER_37_333 VGND VGND VPWR VPWR sky130_fd_sc_hd__decap_3
XFILLER_52_336 VGND VGND VPWR VPWR sky130_fd_sc_hd__decap_3
XFILLER_20_211 VGND VGND VPWR VPWR sky130_fd_sc_hd__decap_3
X_1998_ _1998_/A _1998_/B VGND VGND VPWR VPWR _2062_/A sky130_fd_sc_hd__nor2_1
X_2619_ _2673_/A _2673_/B _2618_/B _2613_/Y VGND VGND VPWR VPWR _2619_/X sky130_fd_sc_hd__a31o_1
XFILLER_47_119 VGND VGND VPWR VPWR sky130_fd_sc_hd__decap_3
XFILLER_47_108 VGND VGND VPWR VPWR sky130_fd_sc_hd__decap_3
XFILLER_55_152 VGND VGND VPWR VPWR sky130_fd_sc_hd__decap_3
XFILLER_28_355 VGND VGND VPWR VPWR sky130_fd_sc_hd__decap_3
XTAP_TAPCELL_ROW_38_361 VGND VPWR sky130_fd_sc_hd__tapvpwrvgnd_1
XFILLER_43_303 VGND VGND VPWR VPWR sky130_fd_sc_hd__decap_3
XFILLER_18_88 VGND VGND VPWR VPWR sky130_fd_sc_hd__fill_1
XFILLER_55_196 VGND VGND VPWR VPWR sky130_fd_sc_hd__decap_3
XFILLER_43_347 VGND VGND VPWR VPWR sky130_fd_sc_hd__fill_1
XFILLER_34_21 VGND VGND VPWR VPWR sky130_fd_sc_hd__decap_3
XTAP_TAPCELL_ROW_13_206 VGND VPWR sky130_fd_sc_hd__tapvpwrvgnd_1
XFILLER_11_211 VGND VGND VPWR VPWR sky130_fd_sc_hd__decap_3
XFILLER_11_255 VGND VGND VPWR VPWR sky130_fd_sc_hd__decap_3
XFILLER_7_215 VGND VGND VPWR VPWR sky130_fd_sc_hd__decap_3
XFILLER_59_51 VGND VGND VPWR VPWR sky130_fd_sc_hd__decap_3
XFILLER_59_84 VGND VGND VPWR VPWR sky130_fd_sc_hd__decap_3
XFILLER_19_311 VGND VGND VPWR VPWR sky130_fd_sc_hd__fill_2
XFILLER_46_141 VGND VGND VPWR VPWR sky130_fd_sc_hd__decap_3
XFILLER_46_130 VGND VGND VPWR VPWR sky130_fd_sc_hd__decap_3
XFILLER_46_174 VGND VGND VPWR VPWR sky130_fd_sc_hd__decap_3
XFILLER_34_336 VGND VGND VPWR VPWR sky130_fd_sc_hd__decap_3
X_1921_ _2441_/A _2222_/A _2033_/A _2222_/C _1839_/C VGND VGND VPWR VPWR _1968_/B
+ sky130_fd_sc_hd__o32a_1
XTAP_TAPCELL_ROW_44_397 VGND VPWR sky130_fd_sc_hd__tapvpwrvgnd_1
X_1852_ _1852_/A _1852_/B VGND VGND VPWR VPWR _1929_/B sky130_fd_sc_hd__and2_1
X_1783_ _1783_/A _1783_/B VGND VGND VPWR VPWR _1784_/B sky130_fd_sc_hd__or2_1
X_2404_ _2404_/A VGND VGND VPWR VPWR _2444_/A sky130_fd_sc_hd__inv_2
Xtt_um_connerdaehler_boop_56 VGND VGND VPWR VPWR tt_um_connerdaehler_boop_56/HI uio_oe[7]
+ sky130_fd_sc_hd__conb_1
X_2335_ _2732_/A _2335_/B VGND VGND VPWR VPWR _2347_/B sky130_fd_sc_hd__and2_1
X_2266_ _2292_/A _2292_/B _2292_/C VGND VGND VPWR VPWR _2293_/A sky130_fd_sc_hd__o21ai_2
XFILLER_29_119 VGND VGND VPWR VPWR sky130_fd_sc_hd__decap_3
X_2197_ _2197_/A _2197_/B VGND VGND VPWR VPWR _2233_/A sky130_fd_sc_hd__xor2_1
XFILLER_25_314 VGND VGND VPWR VPWR sky130_fd_sc_hd__decap_3
XFILLER_52_133 VGND VGND VPWR VPWR sky130_fd_sc_hd__decap_3
XTAP_TAPCELL_ROW_35_342 VGND VPWR sky130_fd_sc_hd__tapvpwrvgnd_1
XFILLER_52_177 VGND VGND VPWR VPWR sky130_fd_sc_hd__decap_3
XFILLER_52_144 VGND VGND VPWR VPWR sky130_fd_sc_hd__decap_3
XFILLER_4_218 VGND VGND VPWR VPWR sky130_fd_sc_hd__decap_3
XFILLER_29_65 VGND VGND VPWR VPWR sky130_fd_sc_hd__decap_3
XFILLER_28_141 VGND VGND VPWR VPWR sky130_fd_sc_hd__decap_3
XTAP_TAPCELL_ROW_58_478 VGND VPWR sky130_fd_sc_hd__tapvpwrvgnd_1
XFILLER_43_133 VGND VGND VPWR VPWR sky130_fd_sc_hd__decap_3
XFILLER_43_111 VGND VGND VPWR VPWR sky130_fd_sc_hd__fill_1
XFILLER_43_166 VGND VGND VPWR VPWR sky130_fd_sc_hd__fill_2
XFILLER_43_144 VGND VGND VPWR VPWR sky130_fd_sc_hd__fill_1
XFILLER_31_317 VGND VGND VPWR VPWR sky130_fd_sc_hd__fill_1
XFILLER_43_188 VGND VGND VPWR VPWR sky130_fd_sc_hd__decap_3
XFILLER_31_328 VGND VGND VPWR VPWR sky130_fd_sc_hd__decap_3
XTAP_TAPCELL_ROW_41_378 VGND VPWR sky130_fd_sc_hd__tapvpwrvgnd_1
XFILLER_6_58 VGND VGND VPWR VPWR sky130_fd_sc_hd__decap_3
XFILLER_6_47 VGND VGND VPWR VPWR sky130_fd_sc_hd__decap_3
XFILLER_3_273 VGND VGND VPWR VPWR sky130_fd_sc_hd__decap_3
X_2120_ _2774_/Q _1465_/A _2336_/A _2117_/Y VGND VGND VPWR VPWR _2121_/B sky130_fd_sc_hd__a31o_1
XTAP_TAPCELL_ROW_49_423 VGND VPWR sky130_fd_sc_hd__tapvpwrvgnd_1
X_2051_ _2051_/A _2051_/B VGND VGND VPWR VPWR _2113_/B sky130_fd_sc_hd__xnor2_1
XFILLER_34_133 VGND VGND VPWR VPWR sky130_fd_sc_hd__fill_1
XFILLER_19_196 VGND VGND VPWR VPWR sky130_fd_sc_hd__fill_1
XTAP_TAPCELL_ROW_32_323 VGND VPWR sky130_fd_sc_hd__tapvpwrvgnd_1
XFILLER_22_317 VGND VGND VPWR VPWR sky130_fd_sc_hd__decap_3
X_1904_ _1976_/A _1976_/B VGND VGND VPWR VPWR _1904_/Y sky130_fd_sc_hd__nand2_1
X_1835_ _1835_/A _1913_/A VGND VGND VPWR VPWR _1837_/A sky130_fd_sc_hd__or2_1
X_1766_ _1770_/A _1770_/B VGND VGND VPWR VPWR _1782_/A sky130_fd_sc_hd__nand2_1
X_1697_ _1698_/B _1698_/A VGND VGND VPWR VPWR _1697_/X sky130_fd_sc_hd__and2b_1
X_2318_ _2297_/B _2297_/C _2297_/A VGND VGND VPWR VPWR _2318_/Y sky130_fd_sc_hd__a21oi_1
XFILLER_57_225 VGND VGND VPWR VPWR sky130_fd_sc_hd__fill_1
XFILLER_57_258 VGND VGND VPWR VPWR sky130_fd_sc_hd__decap_3
X_2249_ _2735_/A _2249_/B _2286_/B VGND VGND VPWR VPWR _2252_/A sky130_fd_sc_hd__or3_1
XFILLER_25_122 VGND VGND VPWR VPWR sky130_fd_sc_hd__decap_3
XFILLER_25_100 VGND VGND VPWR VPWR sky130_fd_sc_hd__decap_3
XFILLER_13_306 VGND VGND VPWR VPWR sky130_fd_sc_hd__fill_2
XTAP_TAPCELL_ROW_55_459 VGND VPWR sky130_fd_sc_hd__tapvpwrvgnd_1
XFILLER_25_155 VGND VGND VPWR VPWR sky130_fd_sc_hd__decap_3
XFILLER_25_199 VGND VGND VPWR VPWR sky130_fd_sc_hd__decap_3
XFILLER_25_177 VGND VGND VPWR VPWR sky130_fd_sc_hd__decap_3
XFILLER_40_169 VGND VGND VPWR VPWR sky130_fd_sc_hd__decap_3
XFILLER_21_350 VGND VGND VPWR VPWR sky130_fd_sc_hd__decap_3
XFILLER_31_66 VGND VGND VPWR VPWR sky130_fd_sc_hd__decap_3
XFILLER_31_99 VGND VGND VPWR VPWR sky130_fd_sc_hd__fill_2
XFILLER_0_265 VGND VGND VPWR VPWR sky130_fd_sc_hd__decap_3
XFILLER_48_203 VGND VGND VPWR VPWR sky130_fd_sc_hd__fill_1
XFILLER_0_298 VGND VGND VPWR VPWR sky130_fd_sc_hd__decap_3
XFILLER_56_41 VGND VGND VPWR VPWR sky130_fd_sc_hd__decap_3
XFILLER_48_269 VGND VGND VPWR VPWR sky130_fd_sc_hd__fill_1
XFILLER_48_247 VGND VGND VPWR VPWR sky130_fd_sc_hd__decap_3
XTAP_TAPCELL_ROW_46_404 VGND VPWR sky130_fd_sc_hd__tapvpwrvgnd_1
XFILLER_56_280 VGND VGND VPWR VPWR sky130_fd_sc_hd__decap_3
XFILLER_16_155 VGND VGND VPWR VPWR sky130_fd_sc_hd__decap_3
XFILLER_16_177 VGND VGND VPWR VPWR sky130_fd_sc_hd__decap_3
XFILLER_8_343 VGND VGND VPWR VPWR sky130_fd_sc_hd__decap_3
X_1620_ _1620_/A _1620_/B VGND VGND VPWR VPWR _1650_/B sky130_fd_sc_hd__and2_1
X_1551_ _1628_/A _1586_/B VGND VGND VPWR VPWR _1572_/B sky130_fd_sc_hd__or2_1
X_1482_ _1483_/B _1483_/C VGND VGND VPWR VPWR _1484_/B sky130_fd_sc_hd__and2_1
XFILLER_39_225 VGND VGND VPWR VPWR sky130_fd_sc_hd__decap_3
XFILLER_39_203 VGND VGND VPWR VPWR sky130_fd_sc_hd__decap_3
X_2103_ _2104_/A _2104_/B _2104_/C VGND VGND VPWR VPWR _2105_/B sky130_fd_sc_hd__o21a_1
X_2034_ _2034_/A _2034_/B VGND VGND VPWR VPWR _2102_/B sky130_fd_sc_hd__and2_1
XFILLER_47_291 VGND VGND VPWR VPWR sky130_fd_sc_hd__decap_3
XFILLER_22_125 VGND VGND VPWR VPWR sky130_fd_sc_hd__decap_3
XTAP_TAPCELL_ROW_60_495 VGND VPWR sky130_fd_sc_hd__tapvpwrvgnd_1
X_1818_ _1819_/A _1819_/B _1819_/C VGND VGND VPWR VPWR _1835_/A sky130_fd_sc_hd__o21a_1
XFILLER_7_90 VGND VGND VPWR VPWR sky130_fd_sc_hd__decap_3
X_1749_ _1752_/A _1752_/B _1743_/X VGND VGND VPWR VPWR _1749_/Y sky130_fd_sc_hd__o21ai_1
XFILLER_45_206 VGND VGND VPWR VPWR sky130_fd_sc_hd__decap_3
XFILLER_60_209 VGND VGND VPWR VPWR sky130_fd_sc_hd__decap_3
XFILLER_13_169 VGND VGND VPWR VPWR sky130_fd_sc_hd__decap_3
XFILLER_9_118 VGND VGND VPWR VPWR sky130_fd_sc_hd__decap_3
XFILLER_42_21 VGND VGND VPWR VPWR sky130_fd_sc_hd__decap_3
XFILLER_42_65 VGND VGND VPWR VPWR sky130_fd_sc_hd__decap_3
XFILLER_5_357 VGND VGND VPWR VPWR sky130_fd_sc_hd__decap_3
XFILLER_3_15 VGND VGND VPWR VPWR sky130_fd_sc_hd__decap_3
XFILLER_3_48 VGND VGND VPWR VPWR sky130_fd_sc_hd__decap_3
XFILLER_44_261 VGND VGND VPWR VPWR sky130_fd_sc_hd__decap_3
XFILLER_12_180 VGND VGND VPWR VPWR sky130_fd_sc_hd__decap_3
X_2721_ _2721_/A _2721_/B VGND VGND VPWR VPWR _2721_/Y sky130_fd_sc_hd__xnor2_1
XFILLER_8_162 VGND VGND VPWR VPWR sky130_fd_sc_hd__decap_3
X_2652_ _2460_/A _2653_/B _2669_/B VGND VGND VPWR VPWR _2652_/X sky130_fd_sc_hd__o21a_1
XFILLER_8_195 VGND VGND VPWR VPWR sky130_fd_sc_hd__fill_1
X_1603_ _1603_/A _1603_/B VGND VGND VPWR VPWR _1604_/B sky130_fd_sc_hd__and2_1
X_2583_ _2583_/A _2583_/B VGND VGND VPWR VPWR _2584_/B sky130_fd_sc_hd__nand2_1
X_1534_ _1534_/A _1899_/A VGND VGND VPWR VPWR _1535_/B sky130_fd_sc_hd__xnor2_1
X_1465_ _1465_/A _1820_/B VGND VGND VPWR VPWR _1467_/B sky130_fd_sc_hd__nor2_1
X_1396_ _1624_/A _1625_/A VGND VGND VPWR VPWR _1663_/A sky130_fd_sc_hd__or2_1
XFILLER_27_217 VGND VGND VPWR VPWR sky130_fd_sc_hd__fill_1
X_2017_ _2372_/A _2372_/B VGND VGND VPWR VPWR _2017_/Y sky130_fd_sc_hd__nand2_1
XFILLER_35_250 VGND VGND VPWR VPWR sky130_fd_sc_hd__decap_3
XFILLER_50_253 VGND VGND VPWR VPWR sky130_fd_sc_hd__decap_3
XFILLER_50_286 VGND VGND VPWR VPWR sky130_fd_sc_hd__decap_3
XFILLER_12_24 VGND VGND VPWR VPWR sky130_fd_sc_hd__decap_3
XFILLER_58_342 VGND VGND VPWR VPWR sky130_fd_sc_hd__decap_3
XFILLER_37_21 VGND VGND VPWR VPWR sky130_fd_sc_hd__decap_3
XFILLER_18_206 VGND VGND VPWR VPWR sky130_fd_sc_hd__decap_3
XFILLER_26_272 VGND VGND VPWR VPWR sky130_fd_sc_hd__decap_3
XFILLER_41_231 VGND VGND VPWR VPWR sky130_fd_sc_hd__decap_3
XFILLER_53_86 VGND VGND VPWR VPWR sky130_fd_sc_hd__fill_1
XFILLER_41_264 VGND VGND VPWR VPWR sky130_fd_sc_hd__decap_3
XFILLER_5_154 VGND VGND VPWR VPWR sky130_fd_sc_hd__fill_2
XFILLER_52_9 VGND VGND VPWR VPWR sky130_fd_sc_hd__decap_3
XFILLER_5_198 VGND VGND VPWR VPWR sky130_fd_sc_hd__decap_3
XFILLER_5_165 VGND VGND VPWR VPWR sky130_fd_sc_hd__decap_3
XFILLER_49_320 VGND VGND VPWR VPWR sky130_fd_sc_hd__decap_3
XTAP_TAPCELL_ROW_19_245 VGND VPWR sky130_fd_sc_hd__tapvpwrvgnd_1
XFILLER_24_209 VGND VGND VPWR VPWR sky130_fd_sc_hd__fill_1
XFILLER_32_253 VGND VGND VPWR VPWR sky130_fd_sc_hd__fill_2
XFILLER_32_286 VGND VGND VPWR VPWR sky130_fd_sc_hd__decap_3
X_2704_ _2696_/A _2672_/X _2703_/X VGND VGND VPWR VPWR _2705_/B sky130_fd_sc_hd__a21oi_2
X_2635_ _2660_/A _2638_/B VGND VGND VPWR VPWR _2649_/B sky130_fd_sc_hd__nor2_1
X_2566_ _2566_/A _2573_/A VGND VGND VPWR VPWR _2570_/B sky130_fd_sc_hd__xnor2_1
X_1517_ _1517_/A _1517_/B VGND VGND VPWR VPWR _1518_/B sky130_fd_sc_hd__xnor2_1
X_2497_ _2473_/A _2512_/A _2498_/A VGND VGND VPWR VPWR _2497_/Y sky130_fd_sc_hd__a21oi_1
XFILLER_59_117 VGND VGND VPWR VPWR sky130_fd_sc_hd__decap_3
X_1448_ _1465_/A _1677_/A VGND VGND VPWR VPWR _1693_/A sky130_fd_sc_hd__nand2_1
XFILLER_4_91 VGND VGND VPWR VPWR sky130_fd_sc_hd__decap_3
X_1379_ _2217_/A VGND VGND VPWR VPWR _1898_/A sky130_fd_sc_hd__inv_2
XFILLER_55_323 VGND VGND VPWR VPWR sky130_fd_sc_hd__decap_3
XFILLER_23_253 VGND VGND VPWR VPWR sky130_fd_sc_hd__fill_2
XFILLER_23_45 VGND VGND VPWR VPWR sky130_fd_sc_hd__decap_3
XFILLER_23_23 VGND VGND VPWR VPWR sky130_fd_sc_hd__decap_3
XFILLER_23_78 VGND VGND VPWR VPWR sky130_fd_sc_hd__fill_2
XFILLER_2_168 VGND VGND VPWR VPWR sky130_fd_sc_hd__decap_3
XFILLER_48_64 VGND VGND VPWR VPWR sky130_fd_sc_hd__fill_1
XFILLER_46_334 VGND VGND VPWR VPWR sky130_fd_sc_hd__decap_3
XFILLER_46_301 VGND VGND VPWR VPWR sky130_fd_sc_hd__fill_1
XFILLER_0_27 VGND VGND VPWR VPWR sky130_fd_sc_hd__fill_1
XFILLER_0_38 VGND VGND VPWR VPWR sky130_fd_sc_hd__decap_3
XFILLER_58_194 VGND VGND VPWR VPWR sky130_fd_sc_hd__fill_2
XTAP_TAPCELL_ROW_16_226 VGND VPWR sky130_fd_sc_hd__tapvpwrvgnd_1
XFILLER_14_253 VGND VGND VPWR VPWR sky130_fd_sc_hd__decap_3
XFILLER_9_47 VGND VGND VPWR VPWR sky130_fd_sc_hd__decap_3
X_2420_ _2420_/A _2420_/B VGND VGND VPWR VPWR _2512_/B sky130_fd_sc_hd__xor2_4
XFILLER_50_6 VGND VGND VPWR VPWR sky130_fd_sc_hd__decap_3
X_2351_ _2346_/X _2356_/C _2292_/A VGND VGND VPWR VPWR _2351_/X sky130_fd_sc_hd__o21a_1
X_2282_ _2282_/A _2282_/B VGND VGND VPWR VPWR _2305_/A sky130_fd_sc_hd__xnor2_1
XFILLER_49_172 VGND VGND VPWR VPWR sky130_fd_sc_hd__fill_2
XFILLER_49_161 VGND VGND VPWR VPWR sky130_fd_sc_hd__decap_3
XFILLER_52_315 VGND VGND VPWR VPWR sky130_fd_sc_hd__decap_3
XFILLER_52_304 VGND VGND VPWR VPWR sky130_fd_sc_hd__decap_3
XFILLER_52_348 VGND VGND VPWR VPWR sky130_fd_sc_hd__decap_3
XFILLER_20_223 VGND VGND VPWR VPWR sky130_fd_sc_hd__decap_3
X_1997_ _1997_/A _2055_/A _1997_/C VGND VGND VPWR VPWR _1998_/B sky130_fd_sc_hd__nor3_1
XFILLER_20_234 VGND VGND VPWR VPWR sky130_fd_sc_hd__decap_3
XFILLER_20_267 VGND VGND VPWR VPWR sky130_fd_sc_hd__decap_3
XFILLER_9_290 VGND VGND VPWR VPWR sky130_fd_sc_hd__decap_3
X_2618_ _2613_/Y _2618_/B VGND VGND VPWR VPWR _2618_/Y sky130_fd_sc_hd__nand2b_1
X_2549_ _2547_/X _2549_/B VGND VGND VPWR VPWR _2630_/A sky130_fd_sc_hd__nand2b_1
XFILLER_18_12 VGND VGND VPWR VPWR sky130_fd_sc_hd__decap_3
XFILLER_55_142 VGND VGND VPWR VPWR sky130_fd_sc_hd__fill_1
XFILLER_55_164 VGND VGND VPWR VPWR sky130_fd_sc_hd__decap_3
XFILLER_43_315 VGND VGND VPWR VPWR sky130_fd_sc_hd__decap_3
XFILLER_18_78 VGND VGND VPWR VPWR sky130_fd_sc_hd__fill_1
XFILLER_34_55 VGND VGND VPWR VPWR sky130_fd_sc_hd__fill_2
XFILLER_11_223 VGND VGND VPWR VPWR sky130_fd_sc_hd__fill_1
XTAP_TAPCELL_ROW_13_207 VGND VPWR sky130_fd_sc_hd__tapvpwrvgnd_1
XFILLER_34_88 VGND VGND VPWR VPWR sky130_fd_sc_hd__decap_3
XFILLER_34_66 VGND VGND VPWR VPWR sky130_fd_sc_hd__decap_3
XFILLER_11_234 VGND VGND VPWR VPWR sky130_fd_sc_hd__decap_3
XFILLER_11_267 VGND VGND VPWR VPWR sky130_fd_sc_hd__fill_2
XFILLER_11_278 VGND VGND VPWR VPWR sky130_fd_sc_hd__fill_2
XFILLER_50_21 VGND VGND VPWR VPWR sky130_fd_sc_hd__decap_3
XFILLER_50_43 VGND VGND VPWR VPWR sky130_fd_sc_hd__decap_3
XFILLER_59_30 VGND VGND VPWR VPWR sky130_fd_sc_hd__decap_3
XFILLER_59_63 VGND VGND VPWR VPWR sky130_fd_sc_hd__decap_3
XFILLER_59_96 VGND VGND VPWR VPWR sky130_fd_sc_hd__decap_3
XFILLER_38_109 VGND VGND VPWR VPWR sky130_fd_sc_hd__decap_3
XFILLER_19_323 VGND VGND VPWR VPWR sky130_fd_sc_hd__decap_3
XFILLER_46_153 VGND VGND VPWR VPWR sky130_fd_sc_hd__decap_3
XFILLER_34_359 VGND VGND VPWR VPWR sky130_fd_sc_hd__fill_2
X_1920_ _1441_/A _1441_/B _1704_/B VGND VGND VPWR VPWR _2222_/C sky130_fd_sc_hd__a21oi_1
X_1851_ _1851_/A _1851_/B _1851_/C VGND VGND VPWR VPWR _1852_/B sky130_fd_sc_hd__or3_1
X_1782_ _1782_/A _1782_/B _1782_/C VGND VGND VPWR VPWR _1782_/X sky130_fd_sc_hd__and3_1
X_2403_ _2566_/A input7/X VGND VGND VPWR VPWR _2404_/A sky130_fd_sc_hd__nand2b_1
X_2334_ _2334_/A _2334_/B VGND VGND VPWR VPWR _2346_/A sky130_fd_sc_hd__xnor2_2
Xtt_um_connerdaehler_boop_57 VGND VGND VPWR VPWR tt_um_connerdaehler_boop_57/HI uio_out[0]
+ sky130_fd_sc_hd__conb_1
XFILLER_29_109 VGND VGND VPWR VPWR sky130_fd_sc_hd__decap_3
X_2265_ _2265_/A _2265_/B VGND VGND VPWR VPWR _2292_/C sky130_fd_sc_hd__xnor2_1
X_2196_ _2196_/A _2196_/B VGND VGND VPWR VPWR _2238_/A sky130_fd_sc_hd__xnor2_1
XFILLER_37_142 VGND VGND VPWR VPWR sky130_fd_sc_hd__decap_3
XFILLER_37_131 VGND VGND VPWR VPWR sky130_fd_sc_hd__fill_1
XFILLER_52_101 VGND VGND VPWR VPWR sky130_fd_sc_hd__decap_3
XFILLER_1_81 VGND VGND VPWR VPWR sky130_fd_sc_hd__decap_3
XFILLER_37_197 VGND VGND VPWR VPWR sky130_fd_sc_hd__decap_3
XFILLER_25_337 VGND VGND VPWR VPWR sky130_fd_sc_hd__fill_2
XTAP_TAPCELL_ROW_35_343 VGND VPWR sky130_fd_sc_hd__tapvpwrvgnd_1
XFILLER_52_156 VGND VGND VPWR VPWR sky130_fd_sc_hd__decap_3
XFILLER_40_307 VGND VGND VPWR VPWR sky130_fd_sc_hd__fill_1
XFILLER_52_189 VGND VGND VPWR VPWR sky130_fd_sc_hd__decap_3
XFILLER_29_88 VGND VGND VPWR VPWR sky130_fd_sc_hd__decap_3
XTAP_TAPCELL_ROW_58_479 VGND VPWR sky130_fd_sc_hd__tapvpwrvgnd_1
XFILLER_45_21 VGND VGND VPWR VPWR sky130_fd_sc_hd__decap_3
XFILLER_28_153 VGND VGND VPWR VPWR sky130_fd_sc_hd__decap_3
XFILLER_16_304 VGND VGND VPWR VPWR sky130_fd_sc_hd__decap_3
XFILLER_28_197 VGND VGND VPWR VPWR sky130_fd_sc_hd__decap_3
XFILLER_28_186 VGND VGND VPWR VPWR sky130_fd_sc_hd__decap_3
XFILLER_16_337 VGND VGND VPWR VPWR sky130_fd_sc_hd__fill_2
XFILLER_45_76 VGND VGND VPWR VPWR sky130_fd_sc_hd__decap_3
XTAP_TAPCELL_ROW_41_379 VGND VPWR sky130_fd_sc_hd__tapvpwrvgnd_1
XFILLER_6_15 VGND VGND VPWR VPWR sky130_fd_sc_hd__decap_3
XFILLER_3_296 VGND VGND VPWR VPWR sky130_fd_sc_hd__decap_3
XFILLER_13_6 VGND VGND VPWR VPWR sky130_fd_sc_hd__decap_3
X_2050_ _2050_/A _2050_/B VGND VGND VPWR VPWR _2051_/B sky130_fd_sc_hd__xnor2_1
XTAP_TAPCELL_ROW_49_424 VGND VPWR sky130_fd_sc_hd__tapvpwrvgnd_1
XFILLER_34_112 VGND VGND VPWR VPWR sky130_fd_sc_hd__fill_2
XFILLER_22_307 VGND VGND VPWR VPWR sky130_fd_sc_hd__fill_1
X_1903_ _2206_/B _1995_/B VGND VGND VPWR VPWR _1976_/B sky130_fd_sc_hd__xnor2_1
XTAP_TAPCELL_ROW_32_324 VGND VPWR sky130_fd_sc_hd__tapvpwrvgnd_1
X_1834_ _1835_/A _1834_/B _1834_/C VGND VGND VPWR VPWR _1913_/A sky130_fd_sc_hd__nor3_1
X_1765_ _1765_/A _1765_/B VGND VGND VPWR VPWR _1770_/B sky130_fd_sc_hd__xnor2_1
X_1696_ _1696_/A _1696_/B VGND VGND VPWR VPWR _1698_/B sky130_fd_sc_hd__xnor2_1
X_2317_ _2334_/A _2334_/B VGND VGND VPWR VPWR _2317_/Y sky130_fd_sc_hd__nand2b_1
X_2248_ _2248_/A _2248_/B VGND VGND VPWR VPWR _2275_/A sky130_fd_sc_hd__xor2_1
XFILLER_57_237 VGND VGND VPWR VPWR sky130_fd_sc_hd__decap_3
X_2179_ _2179_/A _2179_/B VGND VGND VPWR VPWR _2181_/B sky130_fd_sc_hd__xnor2_1
XFILLER_25_134 VGND VGND VPWR VPWR sky130_fd_sc_hd__decap_3
XFILLER_40_104 VGND VGND VPWR VPWR sky130_fd_sc_hd__decap_3
XFILLER_15_57 VGND VGND VPWR VPWR sky130_fd_sc_hd__fill_1
XFILLER_15_24 VGND VGND VPWR VPWR sky130_fd_sc_hd__decap_3
XFILLER_31_78 VGND VGND VPWR VPWR sky130_fd_sc_hd__decap_3
XFILLER_0_200 VGND VGND VPWR VPWR sky130_fd_sc_hd__decap_3
XFILLER_0_277 VGND VGND VPWR VPWR sky130_fd_sc_hd__decap_3
XTAP_TAPCELL_ROW_46_405 VGND VPWR sky130_fd_sc_hd__tapvpwrvgnd_1
XFILLER_56_75 VGND VGND VPWR VPWR sky130_fd_sc_hd__fill_2
XFILLER_56_292 VGND VGND VPWR VPWR sky130_fd_sc_hd__decap_3
XFILLER_16_123 VGND VGND VPWR VPWR sky130_fd_sc_hd__decap_3
XFILLER_16_134 VGND VGND VPWR VPWR sky130_fd_sc_hd__decap_3
XFILLER_31_159 VGND VGND VPWR VPWR sky130_fd_sc_hd__decap_3
XFILLER_8_355 VGND VGND VPWR VPWR sky130_fd_sc_hd__decap_3
X_1550_ _1414_/X _1582_/A _1669_/B VGND VGND VPWR VPWR _1586_/B sky130_fd_sc_hd__a21o_1
X_1481_ _1558_/B _1481_/B VGND VGND VPWR VPWR _1483_/C sky130_fd_sc_hd__or2_1
XFILLER_11_3 VGND VGND VPWR VPWR sky130_fd_sc_hd__fill_2
X_2102_ _2102_/A _2102_/B VGND VGND VPWR VPWR _2104_/C sky130_fd_sc_hd__xor2_1
XFILLER_39_248 VGND VGND VPWR VPWR sky130_fd_sc_hd__decap_3
XFILLER_39_237 VGND VGND VPWR VPWR sky130_fd_sc_hd__decap_3
XFILLER_54_207 VGND VGND VPWR VPWR sky130_fd_sc_hd__decap_3
X_2033_ _2033_/A _2033_/B VGND VGND VPWR VPWR _2102_/A sky130_fd_sc_hd__xnor2_1
XTAP_TAPCELL_ROW_60_496 VGND VPWR sky130_fd_sc_hd__tapvpwrvgnd_1
X_1817_ _1817_/A _1817_/B VGND VGND VPWR VPWR _1819_/C sky130_fd_sc_hd__xnor2_1
XFILLER_30_192 VGND VGND VPWR VPWR sky130_fd_sc_hd__decap_3
X_1748_ _1752_/A _1752_/B VGND VGND VPWR VPWR _1748_/X sky130_fd_sc_hd__or2_1
X_1679_ _1679_/A _1679_/B VGND VGND VPWR VPWR _1824_/B sky130_fd_sc_hd__nor2_1
XFILLER_45_218 VGND VGND VPWR VPWR sky130_fd_sc_hd__decap_3
XFILLER_26_56 VGND VGND VPWR VPWR sky130_fd_sc_hd__decap_3
XFILLER_53_284 VGND VGND VPWR VPWR sky130_fd_sc_hd__decap_3
XFILLER_53_273 VGND VGND VPWR VPWR sky130_fd_sc_hd__decap_3
XFILLER_26_89 VGND VGND VPWR VPWR sky130_fd_sc_hd__fill_1
XFILLER_42_33 VGND VGND VPWR VPWR sky130_fd_sc_hd__decap_3
XFILLER_42_88 VGND VGND VPWR VPWR sky130_fd_sc_hd__decap_3
XFILLER_5_325 VGND VGND VPWR VPWR sky130_fd_sc_hd__decap_3
XFILLER_3_27 VGND VGND VPWR VPWR sky130_fd_sc_hd__decap_3
XFILLER_29_281 VGND VGND VPWR VPWR sky130_fd_sc_hd__decap_3
XFILLER_44_273 VGND VGND VPWR VPWR sky130_fd_sc_hd__decap_3
XFILLER_44_251 VGND VGND VPWR VPWR sky130_fd_sc_hd__fill_1
X_2720_ _2669_/B _2649_/A _2718_/Y _2719_/X _2669_/A VGND VGND VPWR VPWR _2720_/X
+ sky130_fd_sc_hd__o311a_1
XFILLER_8_130 VGND VGND VPWR VPWR sky130_fd_sc_hd__decap_3
XFILLER_12_192 VGND VGND VPWR VPWR sky130_fd_sc_hd__decap_3
X_2651_ _2713_/S VGND VGND VPWR VPWR _2651_/Y sky130_fd_sc_hd__inv_2
X_1602_ _1878_/A _1584_/C _1584_/B VGND VGND VPWR VPWR _1603_/B sky130_fd_sc_hd__o21ai_1
XFILLER_8_174 VGND VGND VPWR VPWR sky130_fd_sc_hd__decap_3
X_2582_ _2549_/B _2630_/B _2547_/X VGND VGND VPWR VPWR _2628_/A sky130_fd_sc_hd__a21o_1
X_1533_ _1671_/A _1608_/B VGND VGND VPWR VPWR _1542_/B sky130_fd_sc_hd__nand2_1
X_1464_ _2762_/Q _1586_/A VGND VGND VPWR VPWR _1972_/A sky130_fd_sc_hd__nand2_4
X_1395_ _2765_/Q _2249_/B VGND VGND VPWR VPWR _1625_/A sky130_fd_sc_hd__nor2_1
X_2016_ _2016_/A _2016_/B VGND VGND VPWR VPWR _2372_/B sky130_fd_sc_hd__xor2_1
XFILLER_35_262 VGND VGND VPWR VPWR sky130_fd_sc_hd__decap_3
XFILLER_50_210 VGND VGND VPWR VPWR sky130_fd_sc_hd__decap_3
XFILLER_10_107 VGND VGND VPWR VPWR sky130_fd_sc_hd__decap_3
XFILLER_50_298 VGND VGND VPWR VPWR sky130_fd_sc_hd__decap_3
XFILLER_2_328 VGND VGND VPWR VPWR sky130_fd_sc_hd__decap_3
XFILLER_58_321 VGND VGND VPWR VPWR sky130_fd_sc_hd__decap_3
XFILLER_58_354 VGND VGND VPWR VPWR sky130_fd_sc_hd__decap_3
XFILLER_37_33 VGND VGND VPWR VPWR sky130_fd_sc_hd__decap_3
XFILLER_37_55 VGND VGND VPWR VPWR sky130_fd_sc_hd__fill_1
XFILLER_18_229 VGND VGND VPWR VPWR sky130_fd_sc_hd__decap_3
XFILLER_26_262 VGND VGND VPWR VPWR sky130_fd_sc_hd__decap_3
XFILLER_53_21 VGND VGND VPWR VPWR sky130_fd_sc_hd__decap_3
XFILLER_26_295 VGND VGND VPWR VPWR sky130_fd_sc_hd__decap_3
XFILLER_41_243 VGND VGND VPWR VPWR sky130_fd_sc_hd__decap_3
XFILLER_53_98 VGND VGND VPWR VPWR sky130_fd_sc_hd__decap_3
XFILLER_41_276 VGND VGND VPWR VPWR sky130_fd_sc_hd__decap_3
XFILLER_5_111 VGND VGND VPWR VPWR sky130_fd_sc_hd__fill_1
XFILLER_45_9 VGND VGND VPWR VPWR sky130_fd_sc_hd__decap_3
XFILLER_49_332 VGND VGND VPWR VPWR sky130_fd_sc_hd__decap_3
XFILLER_49_343 VGND VGND VPWR VPWR sky130_fd_sc_hd__decap_3
XTAP_TAPCELL_ROW_19_246 VGND VPWR sky130_fd_sc_hd__tapvpwrvgnd_1
XFILLER_17_273 VGND VGND VPWR VPWR sky130_fd_sc_hd__decap_3
XFILLER_17_240 VGND VGND VPWR VPWR sky130_fd_sc_hd__decap_3
XFILLER_17_284 VGND VGND VPWR VPWR sky130_fd_sc_hd__decap_3
XTAP_TAPCELL_ROW_27_290 VGND VPWR sky130_fd_sc_hd__tapvpwrvgnd_1
XFILLER_32_265 VGND VGND VPWR VPWR sky130_fd_sc_hd__decap_3
XFILLER_32_243 VGND VGND VPWR VPWR sky130_fd_sc_hd__decap_3
X_2703_ _2669_/B _2699_/Y _2702_/X VGND VGND VPWR VPWR _2703_/X sky130_fd_sc_hd__o21a_1
X_2634_ _2634_/A _2634_/B VGND VGND VPWR VPWR _2638_/B sky130_fd_sc_hd__xor2_1
X_2565_ _2572_/A _2572_/B VGND VGND VPWR VPWR _2573_/A sky130_fd_sc_hd__or2_1
XTAP_TAPCELL_ROW_10_190 VGND VPWR sky130_fd_sc_hd__tapvpwrvgnd_1
X_1516_ _2774_/Q _1986_/C _1824_/A _1501_/X VGND VGND VPWR VPWR _1517_/B sky130_fd_sc_hd__a31o_1
X_2496_ _2496_/A _2496_/B VGND VGND VPWR VPWR _2525_/A sky130_fd_sc_hd__or2_1
X_1447_ _2206_/B _1820_/B VGND VGND VPWR VPWR _1460_/A sky130_fd_sc_hd__nor2_1
XFILLER_4_81 VGND VGND VPWR VPWR sky130_fd_sc_hd__decap_3
X_1378_ _2742_/A VGND VGND VPWR VPWR _1597_/A sky130_fd_sc_hd__inv_2
XFILLER_55_302 VGND VGND VPWR VPWR sky130_fd_sc_hd__decap_3
XFILLER_55_346 VGND VGND VPWR VPWR sky130_fd_sc_hd__decap_3
XFILLER_55_335 VGND VGND VPWR VPWR sky130_fd_sc_hd__fill_1
XFILLER_23_265 VGND VGND VPWR VPWR sky130_fd_sc_hd__decap_3
XFILLER_23_35 VGND VGND VPWR VPWR sky130_fd_sc_hd__decap_3
XFILLER_23_57 VGND VGND VPWR VPWR sky130_fd_sc_hd__decap_3
XFILLER_48_32 VGND VGND VPWR VPWR sky130_fd_sc_hd__decap_3
XFILLER_48_21 VGND VGND VPWR VPWR sky130_fd_sc_hd__decap_3
XFILLER_46_346 VGND VGND VPWR VPWR sky130_fd_sc_hd__decap_3
XTAP_TAPCELL_ROW_16_227 VGND VPWR sky130_fd_sc_hd__tapvpwrvgnd_1
XFILLER_9_15 VGND VGND VPWR VPWR sky130_fd_sc_hd__decap_3
XFILLER_14_265 VGND VGND VPWR VPWR sky130_fd_sc_hd__decap_3
XFILLER_14_287 VGND VGND VPWR VPWR sky130_fd_sc_hd__decap_3
XFILLER_13_90 VGND VGND VPWR VPWR sky130_fd_sc_hd__decap_3
XFILLER_43_6 VGND VGND VPWR VPWR sky130_fd_sc_hd__decap_3
X_2350_ _2350_/A _2350_/B VGND VGND VPWR VPWR _2356_/C sky130_fd_sc_hd__nand2_1
X_2281_ _2245_/A _2246_/Y _2277_/Y _2279_/X VGND VGND VPWR VPWR _2367_/B sky130_fd_sc_hd__a211o_1
XFILLER_49_140 VGND VGND VPWR VPWR sky130_fd_sc_hd__decap_3
XFILLER_1_191 VGND VGND VPWR VPWR sky130_fd_sc_hd__decap_3
XFILLER_37_324 VGND VGND VPWR VPWR sky130_fd_sc_hd__decap_3
XFILLER_37_346 VGND VGND VPWR VPWR sky130_fd_sc_hd__fill_1
XFILLER_52_327 VGND VGND VPWR VPWR sky130_fd_sc_hd__decap_3
X_1996_ _1997_/A _2055_/A _1997_/C VGND VGND VPWR VPWR _1998_/A sky130_fd_sc_hd__o21a_1
XFILLER_20_246 VGND VGND VPWR VPWR sky130_fd_sc_hd__decap_3
X_2617_ _2627_/A _2613_/C _2613_/A VGND VGND VPWR VPWR _2618_/B sky130_fd_sc_hd__o21ai_1
X_2548_ _2548_/A _2548_/B VGND VGND VPWR VPWR _2549_/B sky130_fd_sc_hd__or2_1
X_2479_ _2490_/A _2490_/B VGND VGND VPWR VPWR _2479_/Y sky130_fd_sc_hd__nor2_1
XFILLER_28_335 VGND VGND VPWR VPWR sky130_fd_sc_hd__fill_2
XFILLER_55_187 VGND VGND VPWR VPWR sky130_fd_sc_hd__decap_3
XFILLER_34_12 VGND VGND VPWR VPWR sky130_fd_sc_hd__decap_3
XFILLER_34_45 VGND VGND VPWR VPWR sky130_fd_sc_hd__fill_1
XFILLER_11_202 VGND VGND VPWR VPWR sky130_fd_sc_hd__decap_3
XTAP_TAPCELL_ROW_13_208 VGND VPWR sky130_fd_sc_hd__tapvpwrvgnd_1
XFILLER_34_78 VGND VGND VPWR VPWR sky130_fd_sc_hd__decap_3
XFILLER_11_246 VGND VGND VPWR VPWR sky130_fd_sc_hd__decap_3
Xclkload0 clkload0/A VGND VGND VPWR VPWR clkload0/X sky130_fd_sc_hd__clkbuf_8
XFILLER_7_228 VGND VGND VPWR VPWR sky130_fd_sc_hd__decap_3
XFILLER_7_206 VGND VGND VPWR VPWR sky130_fd_sc_hd__decap_3
XFILLER_50_88 VGND VGND VPWR VPWR sky130_fd_sc_hd__decap_3
XFILLER_59_42 VGND VGND VPWR VPWR sky130_fd_sc_hd__decap_3
XFILLER_59_75 VGND VGND VPWR VPWR sky130_fd_sc_hd__decap_3
XFILLER_19_302 VGND VGND VPWR VPWR sky130_fd_sc_hd__decap_3
XFILLER_46_165 VGND VGND VPWR VPWR sky130_fd_sc_hd__decap_3
XPHY_EDGE_ROW_28_Left_89 VGND VGND VPWR VPWR sky130_fd_sc_hd__decap_3
X_1850_ _1851_/A _1851_/B _1851_/C VGND VGND VPWR VPWR _1852_/A sky130_fd_sc_hd__o21ai_1
X_1781_ _1780_/A _1780_/B _2059_/A VGND VGND VPWR VPWR _1781_/Y sky130_fd_sc_hd__o21ai_1
X_2402_ _2402_/A _2402_/B VGND VGND VPWR VPWR _2566_/A sky130_fd_sc_hd__xor2_4
XFILLER_41_3 VGND VGND VPWR VPWR sky130_fd_sc_hd__decap_3
X_2333_ _2321_/B _2321_/C _2321_/A VGND VGND VPWR VPWR _2338_/B sky130_fd_sc_hd__o21ai_1
Xtt_um_connerdaehler_boop_58 VGND VGND VPWR VPWR tt_um_connerdaehler_boop_58/HI uio_out[1]
+ sky130_fd_sc_hd__conb_1
X_2264_ _2264_/A _2726_/A _2265_/B VGND VGND VPWR VPWR _2326_/A sky130_fd_sc_hd__or3_1
X_2195_ _2195_/A _2195_/B _2195_/C VGND VGND VPWR VPWR _2386_/B sky130_fd_sc_hd__or3_1
XFILLER_25_305 VGND VGND VPWR VPWR sky130_fd_sc_hd__decap_3
XFILLER_1_60 VGND VGND VPWR VPWR sky130_fd_sc_hd__decap_3
XFILLER_37_176 VGND VGND VPWR VPWR sky130_fd_sc_hd__decap_3
XFILLER_52_168 VGND VGND VPWR VPWR sky130_fd_sc_hd__decap_3
XFILLER_33_360 VGND VGND VPWR VPWR sky130_fd_sc_hd__fill_1
XFILLER_60_190 VGND VGND VPWR VPWR sky130_fd_sc_hd__decap_3
X_1979_ _1979_/A _1979_/B VGND VGND VPWR VPWR _1980_/C sky130_fd_sc_hd__xor2_1
XFILLER_4_209 VGND VGND VPWR VPWR sky130_fd_sc_hd__decap_3
XFILLER_29_45 VGND VGND VPWR VPWR sky130_fd_sc_hd__decap_3
XFILLER_28_165 VGND VGND VPWR VPWR sky130_fd_sc_hd__fill_2
XFILLER_45_55 VGND VGND VPWR VPWR sky130_fd_sc_hd__fill_1
XFILLER_43_124 VGND VGND VPWR VPWR sky130_fd_sc_hd__decap_3
XFILLER_43_113 VGND VGND VPWR VPWR sky130_fd_sc_hd__fill_2
XFILLER_43_102 VGND VGND VPWR VPWR sky130_fd_sc_hd__decap_3
XFILLER_43_157 VGND VGND VPWR VPWR sky130_fd_sc_hd__decap_3
XFILLER_6_27 VGND VGND VPWR VPWR sky130_fd_sc_hd__fill_1
XFILLER_3_220 VGND VGND VPWR VPWR sky130_fd_sc_hd__decap_3
XFILLER_3_231 VGND VGND VPWR VPWR sky130_fd_sc_hd__decap_3
XFILLER_3_264 VGND VGND VPWR VPWR sky130_fd_sc_hd__decap_3
XTAP_TAPCELL_ROW_49_425 VGND VPWR sky130_fd_sc_hd__tapvpwrvgnd_1
XFILLER_59_290 VGND VGND VPWR VPWR sky130_fd_sc_hd__decap_3
XFILLER_19_154 VGND VGND VPWR VPWR sky130_fd_sc_hd__decap_3
XFILLER_19_187 VGND VGND VPWR VPWR sky130_fd_sc_hd__decap_3
X_1902_ _1902_/A _1902_/B VGND VGND VPWR VPWR _1976_/A sky130_fd_sc_hd__xor2_1
XTAP_TAPCELL_ROW_32_325 VGND VPWR sky130_fd_sc_hd__tapvpwrvgnd_1
XFILLER_42_190 VGND VGND VPWR VPWR sky130_fd_sc_hd__decap_3
XFILLER_30_330 VGND VGND VPWR VPWR sky130_fd_sc_hd__decap_3
XFILLER_30_352 VGND VGND VPWR VPWR sky130_fd_sc_hd__decap_3
X_1833_ _1833_/A _1833_/B VGND VGND VPWR VPWR _1834_/C sky130_fd_sc_hd__xor2_1
X_1764_ _1775_/A _1764_/B VGND VGND VPWR VPWR _1770_/A sky130_fd_sc_hd__xor2_1
X_1695_ _1695_/A _1695_/B VGND VGND VPWR VPWR _1696_/B sky130_fd_sc_hd__nor2_1
X_2316_ _2770_/Q _2221_/B _2315_/B _2336_/A VGND VGND VPWR VPWR _2334_/B sky130_fd_sc_hd__a22o_1
X_2247_ _2247_/A _2247_/B VGND VGND VPWR VPWR _2278_/A sky130_fd_sc_hd__xor2_1
XFILLER_57_249 VGND VGND VPWR VPWR sky130_fd_sc_hd__decap_3
X_2178_ _2179_/A _2179_/B VGND VGND VPWR VPWR _2178_/Y sky130_fd_sc_hd__nand2_1
XFILLER_25_113 VGND VGND VPWR VPWR sky130_fd_sc_hd__decap_3
XFILLER_25_146 VGND VGND VPWR VPWR sky130_fd_sc_hd__decap_3
XFILLER_40_116 VGND VGND VPWR VPWR sky130_fd_sc_hd__fill_2
XFILLER_31_57 VGND VGND VPWR VPWR sky130_fd_sc_hd__fill_1
XFILLER_0_223 VGND VGND VPWR VPWR sky130_fd_sc_hd__fill_1
XFILLER_56_32 VGND VGND VPWR VPWR sky130_fd_sc_hd__decap_3
XFILLER_56_21 VGND VGND VPWR VPWR sky130_fd_sc_hd__decap_3
XFILLER_48_227 VGND VGND VPWR VPWR sky130_fd_sc_hd__decap_3
XTAP_TAPCELL_ROW_46_406 VGND VPWR sky130_fd_sc_hd__tapvpwrvgnd_1
XFILLER_56_98 VGND VGND VPWR VPWR sky130_fd_sc_hd__decap_3
XFILLER_56_271 VGND VGND VPWR VPWR sky130_fd_sc_hd__decap_3
XPHY_EDGE_ROW_19_Right_19 VGND VGND VPWR VPWR sky130_fd_sc_hd__decap_3
XFILLER_12_330 VGND VGND VPWR VPWR sky130_fd_sc_hd__decap_3
XFILLER_31_138 VGND VGND VPWR VPWR sky130_fd_sc_hd__fill_2
XFILLER_24_190 VGND VGND VPWR VPWR sky130_fd_sc_hd__decap_3
XFILLER_8_312 VGND VGND VPWR VPWR sky130_fd_sc_hd__decap_3
XFILLER_8_334 VGND VGND VPWR VPWR sky130_fd_sc_hd__decap_3
XPHY_EDGE_ROW_28_Right_28 VGND VGND VPWR VPWR sky130_fd_sc_hd__decap_3
XFILLER_21_90 VGND VGND VPWR VPWR sky130_fd_sc_hd__decap_3
X_1480_ _1558_/B _1481_/B VGND VGND VPWR VPWR _1483_/B sky130_fd_sc_hd__nand2_1
X_2101_ _2160_/A _2160_/B VGND VGND VPWR VPWR _2105_/A sky130_fd_sc_hd__or2_1
X_2032_ _1967_/B _2029_/X _2028_/Y wire19/X VGND VGND VPWR VPWR _2041_/B sky130_fd_sc_hd__a211oi_1
XPHY_EDGE_ROW_37_Right_37 VGND VGND VPWR VPWR sky130_fd_sc_hd__decap_3
XFILLER_54_219 VGND VGND VPWR VPWR sky130_fd_sc_hd__decap_3
XFILLER_15_190 VGND VGND VPWR VPWR sky130_fd_sc_hd__decap_3
XTAP_TAPCELL_ROW_60_497 VGND VPWR sky130_fd_sc_hd__tapvpwrvgnd_1
XFILLER_30_160 VGND VGND VPWR VPWR sky130_fd_sc_hd__decap_3
X_1816_ _1894_/A _1894_/B VGND VGND VPWR VPWR _1819_/B sky130_fd_sc_hd__and2_1
XPHY_EDGE_ROW_46_Right_46 VGND VGND VPWR VPWR sky130_fd_sc_hd__decap_3
XFILLER_7_81 VGND VGND VPWR VPWR sky130_fd_sc_hd__decap_3
X_1747_ _1775_/A _1747_/B VGND VGND VPWR VPWR _1751_/A sky130_fd_sc_hd__xnor2_1
XPHY_EDGE_ROW_15_Left_76 VGND VGND VPWR VPWR sky130_fd_sc_hd__decap_3
X_1678_ _1677_/A _1985_/B _1899_/A VGND VGND VPWR VPWR _1679_/B sky130_fd_sc_hd__a21oi_1
XPHY_EDGE_ROW_55_Right_55 VGND VGND VPWR VPWR sky130_fd_sc_hd__decap_3
XFILLER_38_282 VGND VGND VPWR VPWR sky130_fd_sc_hd__fill_1
XFILLER_53_241 VGND VGND VPWR VPWR sky130_fd_sc_hd__fill_1
XFILLER_13_105 VGND VGND VPWR VPWR sky130_fd_sc_hd__decap_3
XFILLER_26_68 VGND VGND VPWR VPWR sky130_fd_sc_hd__fill_2
XFILLER_53_296 VGND VGND VPWR VPWR sky130_fd_sc_hd__decap_3
XFILLER_42_12 VGND VGND VPWR VPWR sky130_fd_sc_hd__decap_3
XFILLER_42_45 VGND VGND VPWR VPWR sky130_fd_sc_hd__decap_3
XFILLER_21_193 VGND VGND VPWR VPWR sky130_fd_sc_hd__decap_3
XFILLER_5_337 VGND VGND VPWR VPWR sky130_fd_sc_hd__decap_3
XFILLER_5_348 VGND VGND VPWR VPWR sky130_fd_sc_hd__decap_3
XFILLER_3_39 VGND VGND VPWR VPWR sky130_fd_sc_hd__decap_3
XFILLER_36_208 VGND VGND VPWR VPWR sky130_fd_sc_hd__decap_3
XFILLER_44_230 VGND VGND VPWR VPWR sky130_fd_sc_hd__decap_3
XFILLER_44_296 VGND VGND VPWR VPWR sky130_fd_sc_hd__decap_3
XFILLER_44_285 VGND VGND VPWR VPWR sky130_fd_sc_hd__decap_3
X_2650_ _2669_/A _2650_/B VGND VGND VPWR VPWR _2713_/S sky130_fd_sc_hd__nor2_1
X_1601_ _1628_/A _1601_/B VGND VGND VPWR VPWR _1631_/A sky130_fd_sc_hd__xnor2_1
XFILLER_8_197 VGND VGND VPWR VPWR sky130_fd_sc_hd__decap_3
XFILLER_8_186 VGND VGND VPWR VPWR sky130_fd_sc_hd__decap_3
X_2581_ _2626_/A _2626_/B _2553_/Y VGND VGND VPWR VPWR _2630_/B sky130_fd_sc_hd__a21o_1
X_1532_ _1542_/A _1532_/B VGND VGND VPWR VPWR _1608_/B sky130_fd_sc_hd__and2_1
X_1463_ _2732_/A _1586_/A VGND VGND VPWR VPWR _1899_/A sky130_fd_sc_hd__and2_2
X_1394_ _1656_/A _2335_/B VGND VGND VPWR VPWR _1624_/A sky130_fd_sc_hd__nor2_1
XFILLER_27_208 VGND VGND VPWR VPWR sky130_fd_sc_hd__decap_3
X_2015_ _2077_/A _2077_/B _2077_/C VGND VGND VPWR VPWR _2372_/A sky130_fd_sc_hd__o21a_1
XFILLER_50_200 VGND VGND VPWR VPWR sky130_fd_sc_hd__fill_2
XFILLER_35_274 VGND VGND VPWR VPWR sky130_fd_sc_hd__fill_2
XFILLER_35_241 VGND VGND VPWR VPWR sky130_fd_sc_hd__decap_3
XFILLER_50_277 VGND VGND VPWR VPWR sky130_fd_sc_hd__decap_3
XFILLER_12_15 VGND VGND VPWR VPWR sky130_fd_sc_hd__decap_3
XFILLER_12_37 VGND VGND VPWR VPWR sky130_fd_sc_hd__fill_1
XFILLER_2_307 VGND VGND VPWR VPWR sky130_fd_sc_hd__fill_1
XFILLER_5_9 VGND VGND VPWR VPWR sky130_fd_sc_hd__decap_3
XFILLER_58_333 VGND VGND VPWR VPWR sky130_fd_sc_hd__decap_3
XFILLER_37_12 VGND VGND VPWR VPWR sky130_fd_sc_hd__decap_3
XFILLER_37_67 VGND VGND VPWR VPWR sky130_fd_sc_hd__decap_3
XFILLER_37_45 VGND VGND VPWR VPWR sky130_fd_sc_hd__fill_1
XFILLER_37_89 VGND VGND VPWR VPWR sky130_fd_sc_hd__decap_3
XFILLER_53_33 VGND VGND VPWR VPWR sky130_fd_sc_hd__decap_3
XFILLER_41_222 VGND VGND VPWR VPWR sky130_fd_sc_hd__fill_2
XFILLER_41_200 VGND VGND VPWR VPWR sky130_fd_sc_hd__decap_3
XFILLER_53_55 VGND VGND VPWR VPWR sky130_fd_sc_hd__fill_1
XFILLER_41_255 VGND VGND VPWR VPWR sky130_fd_sc_hd__decap_3
XFILLER_5_123 VGND VGND VPWR VPWR sky130_fd_sc_hd__decap_3
XFILLER_5_178 VGND VGND VPWR VPWR sky130_fd_sc_hd__decap_3
XFILLER_38_9 VGND VGND VPWR VPWR sky130_fd_sc_hd__decap_3
XFILLER_1_351 VGND VGND VPWR VPWR sky130_fd_sc_hd__decap_3
XFILLER_49_311 VGND VGND VPWR VPWR sky130_fd_sc_hd__decap_3
XFILLER_49_355 VGND VGND VPWR VPWR sky130_fd_sc_hd__decap_3
XTAP_TAPCELL_ROW_19_247 VGND VPWR sky130_fd_sc_hd__tapvpwrvgnd_1
XFILLER_17_263 VGND VGND VPWR VPWR sky130_fd_sc_hd__decap_3
XFILLER_32_222 VGND VGND VPWR VPWR sky130_fd_sc_hd__fill_2
XFILLER_32_200 VGND VGND VPWR VPWR sky130_fd_sc_hd__decap_3
XTAP_TAPCELL_ROW_27_291 VGND VPWR sky130_fd_sc_hd__tapvpwrvgnd_1
X_2702_ _2429_/Y _2669_/Y _2701_/Y _2669_/A _2696_/A VGND VGND VPWR VPWR _2702_/X
+ sky130_fd_sc_hd__o221a_1
X_2633_ _2691_/A _2691_/B _2699_/B _2633_/D VGND VGND VPWR VPWR _2649_/A sky130_fd_sc_hd__and4bb_2
X_2564_ _2564_/A _2614_/A VGND VGND VPWR VPWR _2569_/A sky130_fd_sc_hd__xor2_1
XTAP_TAPCELL_ROW_10_191 VGND VPWR sky130_fd_sc_hd__tapvpwrvgnd_1
X_1515_ _1518_/A VGND VGND VPWR VPWR _1515_/Y sky130_fd_sc_hd__inv_2
X_2495_ _2472_/Y _2536_/A _2535_/B _2530_/A VGND VGND VPWR VPWR _2496_/B sky130_fd_sc_hd__o211a_1
X_1446_ _2777_/Q _1456_/B VGND VGND VPWR VPWR _1677_/A sky130_fd_sc_hd__nand2_1
X_1377_ _2021_/A VGND VGND VPWR VPWR _1405_/A sky130_fd_sc_hd__inv_2
XFILLER_55_314 VGND VGND VPWR VPWR sky130_fd_sc_hd__decap_3
XFILLER_55_358 VGND VGND VPWR VPWR sky130_fd_sc_hd__decap_3
XFILLER_23_211 VGND VGND VPWR VPWR sky130_fd_sc_hd__fill_2
XFILLER_23_299 VGND VGND VPWR VPWR sky130_fd_sc_hd__decap_3
XFILLER_23_277 VGND VGND VPWR VPWR sky130_fd_sc_hd__decap_3
XFILLER_23_14 VGND VGND VPWR VPWR sky130_fd_sc_hd__decap_3
XFILLER_23_69 VGND VGND VPWR VPWR sky130_fd_sc_hd__decap_3
XFILLER_3_6 VGND VGND VPWR VPWR sky130_fd_sc_hd__decap_3
XFILLER_2_159 VGND VGND VPWR VPWR sky130_fd_sc_hd__decap_3
XPHY_EDGE_ROW_45_Left_106 VGND VGND VPWR VPWR sky130_fd_sc_hd__decap_3
XFILLER_58_141 VGND VGND VPWR VPWR sky130_fd_sc_hd__decap_3
XFILLER_58_130 VGND VGND VPWR VPWR sky130_fd_sc_hd__fill_1
XFILLER_48_55 VGND VGND VPWR VPWR sky130_fd_sc_hd__decap_3
XFILLER_58_174 VGND VGND VPWR VPWR sky130_fd_sc_hd__decap_3
XFILLER_48_99 VGND VGND VPWR VPWR sky130_fd_sc_hd__fill_1
XFILLER_48_77 VGND VGND VPWR VPWR sky130_fd_sc_hd__decap_3
XFILLER_46_325 VGND VGND VPWR VPWR sky130_fd_sc_hd__decap_3
XFILLER_0_18 VGND VGND VPWR VPWR sky130_fd_sc_hd__decap_3
XFILLER_0_29 VGND VGND VPWR VPWR sky130_fd_sc_hd__decap_3
XFILLER_46_358 VGND VGND VPWR VPWR sky130_fd_sc_hd__decap_3
XFILLER_14_200 VGND VGND VPWR VPWR sky130_fd_sc_hd__decap_3
XTAP_TAPCELL_ROW_16_228 VGND VPWR sky130_fd_sc_hd__tapvpwrvgnd_1
XFILLER_14_244 VGND VGND VPWR VPWR sky130_fd_sc_hd__decap_3
XPHY_EDGE_ROW_54_Left_115 VGND VGND VPWR VPWR sky130_fd_sc_hd__decap_3
XFILLER_14_277 VGND VGND VPWR VPWR sky130_fd_sc_hd__fill_2
XTAP_TAPCELL_ROW_24_272 VGND VPWR sky130_fd_sc_hd__tapvpwrvgnd_1
X_2280_ _2277_/Y _2279_/X _2245_/A _2246_/Y VGND VGND VPWR VPWR _2280_/X sky130_fd_sc_hd__o211a_1
XFILLER_36_6 VGND VGND VPWR VPWR sky130_fd_sc_hd__decap_3
XFILLER_1_181 VGND VGND VPWR VPWR sky130_fd_sc_hd__fill_1
XFILLER_37_303 VGND VGND VPWR VPWR sky130_fd_sc_hd__fill_1
XFILLER_52_339 VGND VGND VPWR VPWR sky130_fd_sc_hd__decap_3
XFILLER_20_214 VGND VGND VPWR VPWR sky130_fd_sc_hd__decap_3
X_1995_ _1995_/A _1995_/B VGND VGND VPWR VPWR _1997_/C sky130_fd_sc_hd__xor2_1
XFILLER_20_258 VGND VGND VPWR VPWR sky130_fd_sc_hd__decap_3
XFILLER_9_281 VGND VGND VPWR VPWR sky130_fd_sc_hd__decap_3
X_2616_ _2673_/A _2673_/B VGND VGND VPWR VPWR _2616_/Y sky130_fd_sc_hd__nand2_1
X_2547_ _2548_/A _2548_/B VGND VGND VPWR VPWR _2547_/X sky130_fd_sc_hd__and2_1
X_2478_ _2478_/A _2490_/A VGND VGND VPWR VPWR _2544_/B sky130_fd_sc_hd__and2_1
X_1429_ _2021_/B _1622_/A VGND VGND VPWR VPWR _1628_/B sky130_fd_sc_hd__xnor2_1
XFILLER_28_303 VGND VGND VPWR VPWR sky130_fd_sc_hd__decap_3
XFILLER_55_155 VGND VGND VPWR VPWR sky130_fd_sc_hd__fill_2
XFILLER_43_306 VGND VGND VPWR VPWR sky130_fd_sc_hd__decap_3
XFILLER_28_358 VGND VGND VPWR VPWR sky130_fd_sc_hd__decap_3
XFILLER_55_199 VGND VGND VPWR VPWR sky130_fd_sc_hd__decap_3
XFILLER_43_328 VGND VGND VPWR VPWR sky130_fd_sc_hd__decap_3
XFILLER_34_24 VGND VGND VPWR VPWR sky130_fd_sc_hd__decap_3
XFILLER_11_214 VGND VGND VPWR VPWR sky130_fd_sc_hd__decap_3
XTAP_TAPCELL_ROW_13_209 VGND VPWR sky130_fd_sc_hd__tapvpwrvgnd_1
XFILLER_11_225 VGND VGND VPWR VPWR sky130_fd_sc_hd__decap_3
XFILLER_11_258 VGND VGND VPWR VPWR sky130_fd_sc_hd__decap_3
XFILLER_7_218 VGND VGND VPWR VPWR sky130_fd_sc_hd__fill_1
XFILLER_50_12 VGND VGND VPWR VPWR sky130_fd_sc_hd__decap_3
XFILLER_50_34 VGND VGND VPWR VPWR sky130_fd_sc_hd__decap_3
XFILLER_59_21 VGND VGND VPWR VPWR sky130_fd_sc_hd__decap_3
XFILLER_1_3 VGND VGND VPWR VPWR sky130_fd_sc_hd__decap_3
XFILLER_59_54 VGND VGND VPWR VPWR sky130_fd_sc_hd__fill_2
XPHY_EDGE_ROW_3_Left_64 VGND VGND VPWR VPWR sky130_fd_sc_hd__decap_3
XFILLER_59_87 VGND VGND VPWR VPWR sky130_fd_sc_hd__decap_3
XFILLER_46_100 VGND VGND VPWR VPWR sky130_fd_sc_hd__decap_3
XFILLER_46_133 VGND VGND VPWR VPWR sky130_fd_sc_hd__decap_3
XFILLER_46_144 VGND VGND VPWR VPWR sky130_fd_sc_hd__decap_3
XFILLER_46_177 VGND VGND VPWR VPWR sky130_fd_sc_hd__decap_3
XFILLER_34_339 VGND VGND VPWR VPWR sky130_fd_sc_hd__decap_3
X_1780_ _1780_/A _1780_/B VGND VGND VPWR VPWR _1780_/Y sky130_fd_sc_hd__nand2_1
XFILLER_10_291 VGND VGND VPWR VPWR sky130_fd_sc_hd__fill_2
XFILLER_6_251 VGND VGND VPWR VPWR sky130_fd_sc_hd__fill_1
X_2401_ _2434_/B _2401_/B VGND VGND VPWR VPWR _2439_/A sky130_fd_sc_hd__and2_1
X_2332_ _2332_/A _2332_/B VGND VGND VPWR VPWR _2360_/A sky130_fd_sc_hd__and2_1
Xtt_um_connerdaehler_boop_59 VGND VGND VPWR VPWR tt_um_connerdaehler_boop_59/HI uio_out[2]
+ sky130_fd_sc_hd__conb_1
XFILLER_34_3 VGND VGND VPWR VPWR sky130_fd_sc_hd__decap_3
X_2263_ _2263_/A _2263_/B VGND VGND VPWR VPWR _2265_/B sky130_fd_sc_hd__xor2_1
X_2194_ _2195_/B _2195_/C _2195_/A VGND VGND VPWR VPWR _2194_/X sky130_fd_sc_hd__o21a_1
XFILLER_37_111 VGND VGND VPWR VPWR sky130_fd_sc_hd__fill_1
XFILLER_1_72 VGND VGND VPWR VPWR sky130_fd_sc_hd__decap_3
XFILLER_37_188 VGND VGND VPWR VPWR sky130_fd_sc_hd__decap_3
XFILLER_25_317 VGND VGND VPWR VPWR sky130_fd_sc_hd__fill_2
XFILLER_52_147 VGND VGND VPWR VPWR sky130_fd_sc_hd__decap_3
XFILLER_52_136 VGND VGND VPWR VPWR sky130_fd_sc_hd__decap_3
X_1978_ _1979_/A _1979_/B VGND VGND VPWR VPWR _1978_/X sky130_fd_sc_hd__and2b_1
XFILLER_29_68 VGND VGND VPWR VPWR sky130_fd_sc_hd__decap_3
XFILLER_29_57 VGND VGND VPWR VPWR sky130_fd_sc_hd__fill_1
XFILLER_28_122 VGND VGND VPWR VPWR sky130_fd_sc_hd__decap_3
XFILLER_28_111 VGND VGND VPWR VPWR sky130_fd_sc_hd__fill_1
XFILLER_45_12 VGND VGND VPWR VPWR sky130_fd_sc_hd__decap_3
XFILLER_28_144 VGND VGND VPWR VPWR sky130_fd_sc_hd__decap_3
XFILLER_28_133 VGND VGND VPWR VPWR sky130_fd_sc_hd__decap_3
XFILLER_45_67 VGND VGND VPWR VPWR sky130_fd_sc_hd__decap_3
XFILLER_43_136 VGND VGND VPWR VPWR sky130_fd_sc_hd__decap_3
XFILLER_43_169 VGND VGND VPWR VPWR sky130_fd_sc_hd__decap_3
XFILLER_10_70 VGND VGND VPWR VPWR sky130_fd_sc_hd__decap_3
XFILLER_3_287 VGND VGND VPWR VPWR sky130_fd_sc_hd__decap_3
XFILLER_10_92 VGND VGND VPWR VPWR sky130_fd_sc_hd__decap_3
XTAP_TAPCELL_ROW_49_426 VGND VPWR sky130_fd_sc_hd__tapvpwrvgnd_1
XFILLER_19_122 VGND VGND VPWR VPWR sky130_fd_sc_hd__decap_3
XFILLER_19_111 VGND VGND VPWR VPWR sky130_fd_sc_hd__fill_1
XTAP_TAPCELL_ROW_57_470 VGND VPWR sky130_fd_sc_hd__tapvpwrvgnd_1
XFILLER_19_177 VGND VGND VPWR VPWR sky130_fd_sc_hd__decap_3
XFILLER_34_158 VGND VGND VPWR VPWR sky130_fd_sc_hd__decap_3
XFILLER_22_309 VGND VGND VPWR VPWR sky130_fd_sc_hd__fill_2
X_1901_ _2057_/A _1901_/B _2336_/B VGND VGND VPWR VPWR _1902_/B sky130_fd_sc_hd__or3_1
X_1832_ _1833_/B _1833_/A VGND VGND VPWR VPWR _1856_/B sky130_fd_sc_hd__nand2b_1
XTAP_TAPCELL_ROW_40_370 VGND VPWR sky130_fd_sc_hd__tapvpwrvgnd_1
X_1763_ _1763_/A _1763_/B VGND VGND VPWR VPWR _1764_/B sky130_fd_sc_hd__nand2_1
X_1694_ _1693_/B _1693_/C _1693_/A VGND VGND VPWR VPWR _1695_/B sky130_fd_sc_hd__a21oi_1
X_2315_ _2356_/A _2315_/B VGND VGND VPWR VPWR _2321_/A sky130_fd_sc_hd__or2_1
X_2246_ _2188_/B _2240_/X _2239_/Y _2236_/X VGND VGND VPWR VPWR _2246_/Y sky130_fd_sc_hd__o211ai_1
X_2177_ _2177_/A _2177_/B VGND VGND VPWR VPWR _2179_/B sky130_fd_sc_hd__xnor2_1
XFILLER_25_103 VGND VGND VPWR VPWR sky130_fd_sc_hd__decap_3
XFILLER_25_125 VGND VGND VPWR VPWR sky130_fd_sc_hd__decap_3
XFILLER_15_15 VGND VGND VPWR VPWR sky130_fd_sc_hd__decap_3
XFILLER_40_128 VGND VGND VPWR VPWR sky130_fd_sc_hd__decap_3
XFILLER_21_353 VGND VGND VPWR VPWR sky130_fd_sc_hd__decap_3
XFILLER_31_69 VGND VGND VPWR VPWR sky130_fd_sc_hd__decap_3
XFILLER_56_44 VGND VGND VPWR VPWR sky130_fd_sc_hd__decap_3
XTAP_TAPCELL_ROW_46_407 VGND VPWR sky130_fd_sc_hd__tapvpwrvgnd_1
XFILLER_56_283 VGND VGND VPWR VPWR sky130_fd_sc_hd__decap_3
XFILLER_56_250 VGND VGND VPWR VPWR sky130_fd_sc_hd__fill_2
XFILLER_16_158 VGND VGND VPWR VPWR sky130_fd_sc_hd__decap_3
XFILLER_12_342 VGND VGND VPWR VPWR sky130_fd_sc_hd__decap_3
XFILLER_8_346 VGND VGND VPWR VPWR sky130_fd_sc_hd__decap_3
XFILLER_39_206 VGND VGND VPWR VPWR sky130_fd_sc_hd__decap_3
X_2100_ _2100_/A _2171_/A VGND VGND VPWR VPWR _2160_/B sky130_fd_sc_hd__xor2_1
XFILLER_39_228 VGND VGND VPWR VPWR sky130_fd_sc_hd__decap_3
X_2031_ wire19/X _2028_/Y _2029_/X _1967_/B VGND VGND VPWR VPWR _2031_/Y sky130_fd_sc_hd__o211ai_2
XFILLER_47_261 VGND VGND VPWR VPWR sky130_fd_sc_hd__decap_3
XFILLER_47_294 VGND VGND VPWR VPWR sky130_fd_sc_hd__decap_3
XFILLER_22_128 VGND VGND VPWR VPWR sky130_fd_sc_hd__decap_3
XTAP_TAPCELL_ROW_60_498 VGND VPWR sky130_fd_sc_hd__tapvpwrvgnd_1
X_1815_ _1815_/A _1815_/B VGND VGND VPWR VPWR _1894_/B sky130_fd_sc_hd__xnor2_1
X_1746_ _1774_/A _1746_/B VGND VGND VPWR VPWR _1747_/B sky130_fd_sc_hd__xnor2_1
XFILLER_7_93 VGND VGND VPWR VPWR sky130_fd_sc_hd__decap_3
X_1677_ _1677_/A _1899_/A _2356_/A VGND VGND VPWR VPWR _1679_/A sky130_fd_sc_hd__and3_1
X_2229_ _2230_/A _2230_/B VGND VGND VPWR VPWR _2237_/A sky130_fd_sc_hd__nand2b_1
XFILLER_53_220 VGND VGND VPWR VPWR sky130_fd_sc_hd__decap_3
XFILLER_53_264 VGND VGND VPWR VPWR sky130_fd_sc_hd__decap_3
XFILLER_42_24 VGND VGND VPWR VPWR sky130_fd_sc_hd__decap_3
XFILLER_42_68 VGND VGND VPWR VPWR sky130_fd_sc_hd__decap_3
XFILLER_3_18 VGND VGND VPWR VPWR sky130_fd_sc_hd__decap_3
XTAP_TAPCELL_ROW_8_176 VGND VPWR sky130_fd_sc_hd__tapvpwrvgnd_1
XFILLER_29_261 VGND VGND VPWR VPWR sky130_fd_sc_hd__fill_2
XFILLER_44_264 VGND VGND VPWR VPWR sky130_fd_sc_hd__decap_3
XFILLER_44_242 VGND VGND VPWR VPWR sky130_fd_sc_hd__fill_1
XPHY_EDGE_ROW_32_Left_93 VGND VGND VPWR VPWR sky130_fd_sc_hd__decap_3
XFILLER_16_91 VGND VGND VPWR VPWR sky130_fd_sc_hd__decap_3
XFILLER_8_121 VGND VGND VPWR VPWR sky130_fd_sc_hd__decap_3
XFILLER_12_183 VGND VGND VPWR VPWR sky130_fd_sc_hd__decap_3
X_1600_ _2310_/B _1628_/A _1622_/B _1622_/A VGND VGND VPWR VPWR _1604_/A sky130_fd_sc_hd__a2bb2o_1
XFILLER_8_165 VGND VGND VPWR VPWR sky130_fd_sc_hd__decap_3
X_2580_ _2580_/A _2580_/B VGND VGND VPWR VPWR _2626_/B sky130_fd_sc_hd__xor2_1
X_1531_ _1813_/A _1531_/B _1531_/C VGND VGND VPWR VPWR _1532_/B sky130_fd_sc_hd__or3_1
X_1462_ _1502_/B _1462_/B VGND VGND VPWR VPWR _1743_/S sky130_fd_sc_hd__nand2_1
X_1393_ _2764_/Q _1489_/B VGND VGND VPWR VPWR _2249_/B sky130_fd_sc_hd__xnor2_4
X_2014_ _2014_/A _2014_/B VGND VGND VPWR VPWR _2077_/C sky130_fd_sc_hd__xnor2_1
XFILLER_35_253 VGND VGND VPWR VPWR sky130_fd_sc_hd__decap_3
XFILLER_50_289 VGND VGND VPWR VPWR sky130_fd_sc_hd__decap_3
XFILLER_12_27 VGND VGND VPWR VPWR sky130_fd_sc_hd__fill_1
X_1729_ _1729_/A _1729_/B VGND VGND VPWR VPWR _1729_/Y sky130_fd_sc_hd__nand2_1
XFILLER_58_312 VGND VGND VPWR VPWR sky130_fd_sc_hd__decap_3
XFILLER_58_301 VGND VGND VPWR VPWR sky130_fd_sc_hd__decap_3
XFILLER_58_345 VGND VGND VPWR VPWR sky130_fd_sc_hd__decap_3
XFILLER_37_24 VGND VGND VPWR VPWR sky130_fd_sc_hd__fill_2
XFILLER_26_253 VGND VGND VPWR VPWR sky130_fd_sc_hd__decap_3
XFILLER_26_242 VGND VGND VPWR VPWR sky130_fd_sc_hd__decap_3
XFILLER_53_12 VGND VGND VPWR VPWR sky130_fd_sc_hd__decap_3
XFILLER_41_212 VGND VGND VPWR VPWR sky130_fd_sc_hd__decap_3
XFILLER_26_275 VGND VGND VPWR VPWR sky130_fd_sc_hd__decap_3
XFILLER_41_234 VGND VGND VPWR VPWR sky130_fd_sc_hd__decap_3
XFILLER_41_267 VGND VGND VPWR VPWR sky130_fd_sc_hd__decap_3
XFILLER_5_113 VGND VGND VPWR VPWR sky130_fd_sc_hd__decap_3
XFILLER_5_102 VGND VGND VPWR VPWR sky130_fd_sc_hd__decap_3
XFILLER_49_323 VGND VGND VPWR VPWR sky130_fd_sc_hd__decap_3
XFILLER_27_90 VGND VGND VPWR VPWR sky130_fd_sc_hd__decap_3
XFILLER_17_231 VGND VGND VPWR VPWR sky130_fd_sc_hd__decap_3
XTAP_TAPCELL_ROW_27_292 VGND VPWR sky130_fd_sc_hd__tapvpwrvgnd_1
X_2701_ _2701_/A _2701_/B VGND VGND VPWR VPWR _2701_/Y sky130_fd_sc_hd__nor2_1
X_2632_ _2707_/B _2632_/B _2632_/C VGND VGND VPWR VPWR _2633_/D sky130_fd_sc_hd__and3_1
X_2563_ _2577_/A _2577_/B VGND VGND VPWR VPWR _2563_/X sky130_fd_sc_hd__and2b_1
XTAP_TAPCELL_ROW_10_192 VGND VPWR sky130_fd_sc_hd__tapvpwrvgnd_1
X_1514_ _1456_/Y _1703_/B _1711_/B _1711_/A VGND VGND VPWR VPWR _1518_/A sky130_fd_sc_hd__a2bb2o_1
X_2494_ _2472_/Y _2536_/A _2535_/B VGND VGND VPWR VPWR _2530_/B sky130_fd_sc_hd__o21ai_1
XFILLER_4_190 VGND VGND VPWR VPWR sky130_fd_sc_hd__decap_3
X_1445_ _2775_/Q _1451_/B _2729_/B _1442_/X _2777_/Q VGND VGND VPWR VPWR _1445_/X
+ sky130_fd_sc_hd__o311a_1
XFILLER_4_94 VGND VGND VPWR VPWR sky130_fd_sc_hd__decap_3
XFILLER_4_72 VGND VGND VPWR VPWR sky130_fd_sc_hd__decap_3
XFILLER_55_337 VGND VGND VPWR VPWR sky130_fd_sc_hd__decap_3
XFILLER_55_326 VGND VGND VPWR VPWR sky130_fd_sc_hd__decap_3
XFILLER_23_223 VGND VGND VPWR VPWR sky130_fd_sc_hd__fill_1
XFILLER_23_26 VGND VGND VPWR VPWR sky130_fd_sc_hd__decap_3
XFILLER_23_48 VGND VGND VPWR VPWR sky130_fd_sc_hd__fill_1
XFILLER_48_12 VGND VGND VPWR VPWR sky130_fd_sc_hd__decap_3
XFILLER_58_197 VGND VGND VPWR VPWR sky130_fd_sc_hd__decap_3
XFILLER_58_186 VGND VGND VPWR VPWR sky130_fd_sc_hd__decap_3
XFILLER_46_337 VGND VGND VPWR VPWR sky130_fd_sc_hd__decap_3
XFILLER_14_212 VGND VGND VPWR VPWR sky130_fd_sc_hd__decap_3
XTAP_TAPCELL_ROW_16_229 VGND VPWR sky130_fd_sc_hd__tapvpwrvgnd_1
XFILLER_14_256 VGND VGND VPWR VPWR sky130_fd_sc_hd__decap_3
XTAP_TAPCELL_ROW_24_273 VGND VPWR sky130_fd_sc_hd__tapvpwrvgnd_1
XFILLER_13_81 VGND VGND VPWR VPWR sky130_fd_sc_hd__decap_3
XFILLER_50_9 VGND VGND VPWR VPWR sky130_fd_sc_hd__decap_3
XFILLER_49_164 VGND VGND VPWR VPWR sky130_fd_sc_hd__decap_3
XFILLER_37_315 VGND VGND VPWR VPWR sky130_fd_sc_hd__decap_3
XFILLER_49_197 VGND VGND VPWR VPWR sky130_fd_sc_hd__decap_3
XFILLER_37_337 VGND VGND VPWR VPWR sky130_fd_sc_hd__decap_3
XFILLER_52_307 VGND VGND VPWR VPWR sky130_fd_sc_hd__fill_1
XFILLER_37_359 VGND VGND VPWR VPWR sky130_fd_sc_hd__fill_2
XFILLER_52_318 VGND VGND VPWR VPWR sky130_fd_sc_hd__decap_3
XFILLER_60_340 VGND VGND VPWR VPWR sky130_fd_sc_hd__decap_3
X_1994_ _2054_/A _2054_/B _2054_/C VGND VGND VPWR VPWR _2055_/A sky130_fd_sc_hd__o21a_1
XFILLER_20_237 VGND VGND VPWR VPWR sky130_fd_sc_hd__decap_3
XFILLER_20_226 VGND VGND VPWR VPWR sky130_fd_sc_hd__fill_1
X_2615_ _2610_/B _2614_/Y _2627_/A VGND VGND VPWR VPWR _2673_/B sky130_fd_sc_hd__o21ba_1
X_2546_ _2552_/A _2562_/A VGND VGND VPWR VPWR _2548_/B sky130_fd_sc_hd__and2_1
X_2477_ _2478_/A _2490_/A VGND VGND VPWR VPWR _2544_/A sky130_fd_sc_hd__nor2_1
X_1428_ _1809_/A _2284_/A VGND VGND VPWR VPWR _1628_/A sky130_fd_sc_hd__or2_2
XFILLER_18_15 VGND VGND VPWR VPWR sky130_fd_sc_hd__decap_3
XFILLER_55_167 VGND VGND VPWR VPWR sky130_fd_sc_hd__fill_1
XFILLER_55_178 VGND VGND VPWR VPWR sky130_fd_sc_hd__decap_3
XFILLER_43_318 VGND VGND VPWR VPWR sky130_fd_sc_hd__decap_3
XFILLER_51_340 VGND VGND VPWR VPWR sky130_fd_sc_hd__decap_3
XFILLER_34_36 VGND VGND VPWR VPWR sky130_fd_sc_hd__decap_3
XFILLER_34_69 VGND VGND VPWR VPWR sky130_fd_sc_hd__decap_3
XFILLER_11_237 VGND VGND VPWR VPWR sky130_fd_sc_hd__decap_3
XTAP_TAPCELL_ROW_21_254 VGND VPWR sky130_fd_sc_hd__tapvpwrvgnd_1
XFILLER_50_24 VGND VGND VPWR VPWR sky130_fd_sc_hd__decap_3
XFILLER_50_46 VGND VGND VPWR VPWR sky130_fd_sc_hd__decap_3
XFILLER_59_33 VGND VGND VPWR VPWR sky130_fd_sc_hd__decap_3
XFILLER_59_66 VGND VGND VPWR VPWR sky130_fd_sc_hd__decap_3
XFILLER_59_99 VGND VGND VPWR VPWR sky130_fd_sc_hd__decap_3
XFILLER_46_112 VGND VGND VPWR VPWR sky130_fd_sc_hd__decap_3
XFILLER_19_337 VGND VGND VPWR VPWR sky130_fd_sc_hd__fill_2
XFILLER_46_156 VGND VGND VPWR VPWR sky130_fd_sc_hd__decap_3
XFILLER_42_340 VGND VGND VPWR VPWR sky130_fd_sc_hd__fill_1
XFILLER_24_91 VGND VGND VPWR VPWR sky130_fd_sc_hd__decap_3
X_2400_ input8/X _2483_/A VGND VGND VPWR VPWR _2401_/B sky130_fd_sc_hd__or2_1
XFILLER_6_285 VGND VGND VPWR VPWR sky130_fd_sc_hd__decap_3
X_2331_ _2326_/B _2326_/C _2326_/A VGND VGND VPWR VPWR _2332_/B sky130_fd_sc_hd__o21ai_1
Xtt_um_connerdaehler_boop_49 VGND VGND VPWR VPWR tt_um_connerdaehler_boop_49/HI uio_oe[0]
+ sky130_fd_sc_hd__conb_1
X_2262_ _2262_/A _2263_/B VGND VGND VPWR VPWR _2292_/B sky130_fd_sc_hd__xor2_1
X_2193_ _2243_/A _2243_/B VGND VGND VPWR VPWR _2195_/C sky130_fd_sc_hd__and2b_1
XFILLER_37_145 VGND VGND VPWR VPWR sky130_fd_sc_hd__decap_3
XFILLER_1_51 VGND VGND VPWR VPWR sky130_fd_sc_hd__decap_3
XFILLER_52_104 VGND VGND VPWR VPWR sky130_fd_sc_hd__decap_3
XFILLER_1_95 VGND VGND VPWR VPWR sky130_fd_sc_hd__decap_3
XFILLER_1_84 VGND VGND VPWR VPWR sky130_fd_sc_hd__decap_3
XFILLER_52_159 VGND VGND VPWR VPWR sky130_fd_sc_hd__decap_3
XFILLER_33_351 VGND VGND VPWR VPWR sky130_fd_sc_hd__decap_3
XFILLER_60_181 VGND VGND VPWR VPWR sky130_fd_sc_hd__decap_3
XTAP_TAPCELL_ROW_43_390 VGND VPWR sky130_fd_sc_hd__tapvpwrvgnd_1
X_1977_ _1977_/A _1977_/B VGND VGND VPWR VPWR _1979_/B sky130_fd_sc_hd__xnor2_1
X_2529_ _2529_/A _2529_/B VGND VGND VPWR VPWR _2602_/A sky130_fd_sc_hd__xor2_1
XFILLER_29_36 VGND VGND VPWR VPWR sky130_fd_sc_hd__decap_3
XFILLER_28_156 VGND VGND VPWR VPWR sky130_fd_sc_hd__fill_2
XFILLER_45_24 VGND VGND VPWR VPWR sky130_fd_sc_hd__decap_3
XFILLER_28_189 VGND VGND VPWR VPWR sky130_fd_sc_hd__decap_3
XFILLER_16_307 VGND VGND VPWR VPWR sky130_fd_sc_hd__fill_1
XFILLER_45_79 VGND VGND VPWR VPWR sky130_fd_sc_hd__decap_3
XFILLER_43_148 VGND VGND VPWR VPWR sky130_fd_sc_hd__decap_3
XFILLER_6_29 VGND VGND VPWR VPWR sky130_fd_sc_hd__decap_3
XFILLER_6_18 VGND VGND VPWR VPWR sky130_fd_sc_hd__decap_3
XFILLER_10_82 VGND VGND VPWR VPWR sky130_fd_sc_hd__fill_2
XFILLER_3_299 VGND VGND VPWR VPWR sky130_fd_sc_hd__decap_3
XFILLER_13_9 VGND VGND VPWR VPWR sky130_fd_sc_hd__fill_1
XTAP_TAPCELL_ROW_49_427 VGND VPWR sky130_fd_sc_hd__tapvpwrvgnd_1
XFILLER_59_281 VGND VGND VPWR VPWR sky130_fd_sc_hd__decap_3
XFILLER_59_270 VGND VGND VPWR VPWR sky130_fd_sc_hd__decap_3
XTAP_TAPCELL_ROW_57_471 VGND VPWR sky130_fd_sc_hd__tapvpwrvgnd_1
XFILLER_34_137 VGND VGND VPWR VPWR sky130_fd_sc_hd__decap_3
X_1900_ _2217_/A _2206_/A VGND VGND VPWR VPWR _2336_/B sky130_fd_sc_hd__nor2_1
XFILLER_30_321 VGND VGND VPWR VPWR sky130_fd_sc_hd__fill_1
X_1831_ _1831_/A _1831_/B VGND VGND VPWR VPWR _1833_/B sky130_fd_sc_hd__xor2_1
XFILLER_30_343 VGND VGND VPWR VPWR sky130_fd_sc_hd__decap_3
XTAP_TAPCELL_ROW_40_371 VGND VPWR sky130_fd_sc_hd__tapvpwrvgnd_1
X_1762_ _1774_/A _1762_/B _1762_/C VGND VGND VPWR VPWR _1763_/B sky130_fd_sc_hd__nand3_1
X_1693_ _1693_/A _1693_/B _1693_/C VGND VGND VPWR VPWR _1695_/A sky130_fd_sc_hd__and3_1
X_2314_ _2336_/A _2336_/B VGND VGND VPWR VPWR _2347_/A sky130_fd_sc_hd__and2_1
X_2245_ _2245_/A _2245_/B VGND VGND VPWR VPWR _2367_/A sky130_fd_sc_hd__xnor2_1
X_2176_ _2163_/A _2163_/B _2161_/X VGND VGND VPWR VPWR _2179_/A sky130_fd_sc_hd__a21o_1
XFILLER_25_137 VGND VGND VPWR VPWR sky130_fd_sc_hd__decap_3
XFILLER_40_107 VGND VGND VPWR VPWR sky130_fd_sc_hd__decap_3
XFILLER_15_27 VGND VGND VPWR VPWR sky130_fd_sc_hd__decap_3
XFILLER_33_181 VGND VGND VPWR VPWR sky130_fd_sc_hd__decap_3
XFILLER_21_332 VGND VGND VPWR VPWR sky130_fd_sc_hd__decap_3
XPHY_EDGE_ROW_1_Right_1 VGND VGND VPWR VPWR sky130_fd_sc_hd__decap_3
XFILLER_0_203 VGND VGND VPWR VPWR sky130_fd_sc_hd__decap_3
XFILLER_0_214 VGND VGND VPWR VPWR sky130_fd_sc_hd__decap_3
XFILLER_0_225 VGND VGND VPWR VPWR sky130_fd_sc_hd__decap_3
XFILLER_56_12 VGND VGND VPWR VPWR sky130_fd_sc_hd__decap_3
XTAP_TAPCELL_ROW_46_408 VGND VPWR sky130_fd_sc_hd__tapvpwrvgnd_1
XFILLER_56_262 VGND VGND VPWR VPWR sky130_fd_sc_hd__decap_3
XFILLER_56_295 VGND VGND VPWR VPWR sky130_fd_sc_hd__decap_3
XFILLER_16_137 VGND VGND VPWR VPWR sky130_fd_sc_hd__decap_3
XFILLER_16_126 VGND VGND VPWR VPWR sky130_fd_sc_hd__fill_1
XTAP_TAPCELL_ROW_54_452 VGND VPWR sky130_fd_sc_hd__tapvpwrvgnd_1
XFILLER_12_321 VGND VGND VPWR VPWR sky130_fd_sc_hd__decap_3
XFILLER_31_129 VGND VGND VPWR VPWR sky130_fd_sc_hd__decap_3
XFILLER_24_181 VGND VGND VPWR VPWR sky130_fd_sc_hd__decap_3
XFILLER_8_325 VGND VGND VPWR VPWR sky130_fd_sc_hd__decap_3
XFILLER_8_358 VGND VGND VPWR VPWR sky130_fd_sc_hd__decap_3
XFILLER_21_81 VGND VGND VPWR VPWR sky130_fd_sc_hd__decap_3
X_2030_ wire19/X _2028_/Y _2029_/X _1967_/B VGND VGND VPWR VPWR _2041_/A sky130_fd_sc_hd__o211a_1
XFILLER_15_181 VGND VGND VPWR VPWR sky130_fd_sc_hd__fill_1
XTAP_TAPCELL_ROW_60_488 VGND VPWR sky130_fd_sc_hd__tapvpwrvgnd_1
XTAP_TAPCELL_ROW_60_499 VGND VPWR sky130_fd_sc_hd__tapvpwrvgnd_1
X_1814_ _1815_/B _1815_/A VGND VGND VPWR VPWR _1814_/Y sky130_fd_sc_hd__nand2b_1
XFILLER_30_195 VGND VGND VPWR VPWR sky130_fd_sc_hd__fill_1
X_1745_ _1556_/Y _1739_/B _1741_/Y VGND VGND VPWR VPWR _1746_/B sky130_fd_sc_hd__a21bo_1
X_1676_ _1676_/A _1676_/B VGND VGND VPWR VPWR _1836_/A sky130_fd_sc_hd__nand2_1
X_2228_ _2228_/A _2228_/B VGND VGND VPWR VPWR _2230_/B sky130_fd_sc_hd__and2_1
XFILLER_38_273 VGND VGND VPWR VPWR sky130_fd_sc_hd__decap_3
XFILLER_38_240 VGND VGND VPWR VPWR sky130_fd_sc_hd__decap_3
X_2159_ _2159_/A _2159_/B VGND VGND VPWR VPWR _2162_/A sky130_fd_sc_hd__and2_1
XFILLER_53_232 VGND VGND VPWR VPWR sky130_fd_sc_hd__fill_1
XFILLER_26_59 VGND VGND VPWR VPWR sky130_fd_sc_hd__decap_3
XFILLER_53_287 VGND VGND VPWR VPWR sky130_fd_sc_hd__decap_3
XFILLER_53_276 VGND VGND VPWR VPWR sky130_fd_sc_hd__decap_3
XFILLER_42_36 VGND VGND VPWR VPWR sky130_fd_sc_hd__decap_3
XFILLER_21_162 VGND VGND VPWR VPWR sky130_fd_sc_hd__decap_3
XFILLER_5_328 VGND VGND VPWR VPWR sky130_fd_sc_hd__decap_3
XTAP_TAPCELL_ROW_8_177 VGND VPWR sky130_fd_sc_hd__tapvpwrvgnd_1
XFILLER_29_240 VGND VGND VPWR VPWR sky130_fd_sc_hd__decap_3
XFILLER_44_210 VGND VGND VPWR VPWR sky130_fd_sc_hd__fill_2
XFILLER_29_284 VGND VGND VPWR VPWR sky130_fd_sc_hd__decap_3
XFILLER_44_276 VGND VGND VPWR VPWR sky130_fd_sc_hd__decap_3
XFILLER_16_81 VGND VGND VPWR VPWR sky130_fd_sc_hd__decap_3
XFILLER_12_151 VGND VGND VPWR VPWR sky130_fd_sc_hd__fill_1
XFILLER_8_100 VGND VGND VPWR VPWR sky130_fd_sc_hd__decap_3
XFILLER_12_195 VGND VGND VPWR VPWR sky130_fd_sc_hd__fill_1
XFILLER_8_133 VGND VGND VPWR VPWR sky130_fd_sc_hd__decap_3
XFILLER_8_177 VGND VGND VPWR VPWR sky130_fd_sc_hd__decap_3
X_1530_ _1531_/B _1531_/C _1813_/A VGND VGND VPWR VPWR _1542_/A sky130_fd_sc_hd__o21ai_1
XFILLER_59_6 VGND VGND VPWR VPWR sky130_fd_sc_hd__decap_3
X_1461_ _1502_/B _1462_/B VGND VGND VPWR VPWR _1558_/B sky130_fd_sc_hd__and2_2
X_1392_ _2764_/Q _1438_/B VGND VGND VPWR VPWR _2335_/B sky130_fd_sc_hd__xnor2_4
X_2013_ _2077_/A _2013_/B _2013_/C VGND VGND VPWR VPWR _2077_/B sky130_fd_sc_hd__nor3_1
XFILLER_35_210 VGND VGND VPWR VPWR sky130_fd_sc_hd__decap_3
XFILLER_35_265 VGND VGND VPWR VPWR sky130_fd_sc_hd__decap_3
XFILLER_50_213 VGND VGND VPWR VPWR sky130_fd_sc_hd__decap_3
XFILLER_50_268 VGND VGND VPWR VPWR sky130_fd_sc_hd__decap_3
X_2777_ _2777_/CLK _2777_/D fanout48/X VGND VGND VPWR VPWR _2777_/Q sky130_fd_sc_hd__dfrtp_4
X_1728_ _1729_/A _1729_/B VGND VGND VPWR VPWR _1868_/B sky130_fd_sc_hd__and2_1
XFILLER_2_309 VGND VGND VPWR VPWR sky130_fd_sc_hd__fill_1
X_1659_ _2286_/A _1660_/B VGND VGND VPWR VPWR _1659_/Y sky130_fd_sc_hd__nor2_1
XFILLER_58_324 VGND VGND VPWR VPWR sky130_fd_sc_hd__decap_3
XTAP_TAPCELL_ROW_5_158 VGND VPWR sky130_fd_sc_hd__tapvpwrvgnd_1
XFILLER_58_357 VGND VGND VPWR VPWR sky130_fd_sc_hd__decap_3
XFILLER_37_36 VGND VGND VPWR VPWR sky130_fd_sc_hd__decap_3
XFILLER_53_24 VGND VGND VPWR VPWR sky130_fd_sc_hd__decap_3
XFILLER_26_298 VGND VGND VPWR VPWR sky130_fd_sc_hd__decap_3
XFILLER_26_265 VGND VGND VPWR VPWR sky130_fd_sc_hd__fill_1
XFILLER_53_57 VGND VGND VPWR VPWR sky130_fd_sc_hd__fill_1
XFILLER_41_246 VGND VGND VPWR VPWR sky130_fd_sc_hd__decap_3
XFILLER_41_279 VGND VGND VPWR VPWR sky130_fd_sc_hd__fill_1
XFILLER_5_169 VGND VGND VPWR VPWR sky130_fd_sc_hd__decap_3
XFILLER_1_342 VGND VGND VPWR VPWR sky130_fd_sc_hd__decap_3
XFILLER_49_302 VGND VGND VPWR VPWR sky130_fd_sc_hd__decap_3
XFILLER_49_346 VGND VGND VPWR VPWR sky130_fd_sc_hd__decap_3
XFILLER_49_335 VGND VGND VPWR VPWR sky130_fd_sc_hd__fill_1
XFILLER_17_210 VGND VGND VPWR VPWR sky130_fd_sc_hd__decap_3
XFILLER_17_254 VGND VGND VPWR VPWR sky130_fd_sc_hd__decap_3
XFILLER_17_243 VGND VGND VPWR VPWR sky130_fd_sc_hd__decap_3
XFILLER_32_213 VGND VGND VPWR VPWR sky130_fd_sc_hd__fill_2
XFILLER_17_287 VGND VGND VPWR VPWR sky130_fd_sc_hd__decap_3
XFILLER_17_276 VGND VGND VPWR VPWR sky130_fd_sc_hd__decap_3
XTAP_TAPCELL_ROW_27_293 VGND VPWR sky130_fd_sc_hd__tapvpwrvgnd_1
XFILLER_32_246 VGND VGND VPWR VPWR sky130_fd_sc_hd__decap_3
XFILLER_32_268 VGND VGND VPWR VPWR sky130_fd_sc_hd__decap_3
X_2700_ _2700_/A _2700_/B _2700_/C VGND VGND VPWR VPWR _2701_/B sky130_fd_sc_hd__and3_1
X_2631_ _2627_/A _2631_/B VGND VGND VPWR VPWR _2632_/C sky130_fd_sc_hd__and2b_1
X_2562_ _2562_/A _2570_/A VGND VGND VPWR VPWR _2577_/B sky130_fd_sc_hd__xnor2_1
XTAP_TAPCELL_ROW_10_193 VGND VPWR sky130_fd_sc_hd__tapvpwrvgnd_1
XFILLER_57_3 VGND VGND VPWR VPWR sky130_fd_sc_hd__decap_3
X_1513_ _2045_/B _1703_/B _1512_/Y VGND VGND VPWR VPWR _1711_/B sky130_fd_sc_hd__o21a_1
X_2493_ _2539_/A _2539_/B _2474_/Y VGND VGND VPWR VPWR _2536_/A sky130_fd_sc_hd__o21bai_2
X_1444_ _2775_/Q _1451_/B _2729_/B _1442_/X VGND VGND VPWR VPWR _1444_/Y sky130_fd_sc_hd__o31ai_2
XFILLER_55_305 VGND VGND VPWR VPWR sky130_fd_sc_hd__decap_3
XFILLER_55_349 VGND VGND VPWR VPWR sky130_fd_sc_hd__decap_3
XFILLER_23_268 VGND VGND VPWR VPWR sky130_fd_sc_hd__decap_3
XFILLER_23_38 VGND VGND VPWR VPWR sky130_fd_sc_hd__fill_2
XFILLER_48_24 VGND VGND VPWR VPWR sky130_fd_sc_hd__decap_3
XFILLER_46_349 VGND VGND VPWR VPWR sky130_fd_sc_hd__decap_3
XFILLER_54_360 VGND VGND VPWR VPWR sky130_fd_sc_hd__fill_1
XFILLER_9_18 VGND VGND VPWR VPWR sky130_fd_sc_hd__fill_1
XFILLER_14_268 VGND VGND VPWR VPWR sky130_fd_sc_hd__decap_3
XTAP_TAPCELL_ROW_24_274 VGND VPWR sky130_fd_sc_hd__tapvpwrvgnd_1
XFILLER_13_60 VGND VGND VPWR VPWR sky130_fd_sc_hd__decap_3
XFILLER_13_93 VGND VGND VPWR VPWR sky130_fd_sc_hd__decap_3
XFILLER_43_9 VGND VGND VPWR VPWR sky130_fd_sc_hd__decap_3
XFILLER_49_132 VGND VGND VPWR VPWR sky130_fd_sc_hd__decap_3
XFILLER_1_194 VGND VGND VPWR VPWR sky130_fd_sc_hd__decap_3
XFILLER_49_143 VGND VGND VPWR VPWR sky130_fd_sc_hd__decap_3
XFILLER_49_187 VGND VGND VPWR VPWR sky130_fd_sc_hd__decap_3
XFILLER_37_327 VGND VGND VPWR VPWR sky130_fd_sc_hd__decap_3
XFILLER_45_360 VGND VGND VPWR VPWR sky130_fd_sc_hd__fill_1
XFILLER_60_330 VGND VGND VPWR VPWR sky130_fd_sc_hd__decap_3
XFILLER_60_352 VGND VGND VPWR VPWR sky130_fd_sc_hd__decap_3
X_1993_ _2037_/A _1993_/B VGND VGND VPWR VPWR _2054_/C sky130_fd_sc_hd__xnor2_1
XFILLER_20_249 VGND VGND VPWR VPWR sky130_fd_sc_hd__decap_3
X_2614_ _2614_/A _2614_/B VGND VGND VPWR VPWR _2614_/Y sky130_fd_sc_hd__nor2_1
X_2545_ _2545_/A _2545_/B VGND VGND VPWR VPWR _2562_/A sky130_fd_sc_hd__xnor2_2
X_2476_ _2474_/Y _2476_/B VGND VGND VPWR VPWR _2539_/A sky130_fd_sc_hd__nand2b_1
X_1427_ _1597_/A _1427_/B VGND VGND VPWR VPWR _2199_/B sky130_fd_sc_hd__xnor2_4
XFILLER_55_146 VGND VGND VPWR VPWR sky130_fd_sc_hd__decap_3
XFILLER_28_349 VGND VGND VPWR VPWR sky130_fd_sc_hd__decap_3
XFILLER_34_15 VGND VGND VPWR VPWR sky130_fd_sc_hd__decap_3
XFILLER_11_205 VGND VGND VPWR VPWR sky130_fd_sc_hd__decap_3
XFILLER_51_352 VGND VGND VPWR VPWR sky130_fd_sc_hd__decap_3
XFILLER_11_249 VGND VGND VPWR VPWR sky130_fd_sc_hd__decap_3
XFILLER_7_209 VGND VGND VPWR VPWR sky130_fd_sc_hd__decap_3
XTAP_TAPCELL_ROW_21_255 VGND VPWR sky130_fd_sc_hd__tapvpwrvgnd_1
XFILLER_59_12 VGND VGND VPWR VPWR sky130_fd_sc_hd__decap_3
XFILLER_59_45 VGND VGND VPWR VPWR sky130_fd_sc_hd__decap_3
XFILLER_59_78 VGND VGND VPWR VPWR sky130_fd_sc_hd__decap_3
XFILLER_19_305 VGND VGND VPWR VPWR sky130_fd_sc_hd__decap_3
XFILLER_46_168 VGND VGND VPWR VPWR sky130_fd_sc_hd__decap_3
XTAP_TAPCELL_ROW_12_200 VGND VPWR sky130_fd_sc_hd__tapvpwrvgnd_1
XFILLER_24_81 VGND VGND VPWR VPWR sky130_fd_sc_hd__decap_3
XFILLER_10_271 VGND VGND VPWR VPWR sky130_fd_sc_hd__decap_3
XFILLER_40_80 VGND VGND VPWR VPWR sky130_fd_sc_hd__decap_3
XFILLER_41_6 VGND VGND VPWR VPWR sky130_fd_sc_hd__decap_3
X_2330_ _2330_/A _2330_/B VGND VGND VPWR VPWR _2402_/A sky130_fd_sc_hd__xnor2_4
X_2261_ _2726_/A _2261_/B VGND VGND VPWR VPWR _2292_/A sky130_fd_sc_hd__nor2_1
X_2192_ _2192_/A _2192_/B VGND VGND VPWR VPWR _2243_/B sky130_fd_sc_hd__xnor2_1
XFILLER_37_113 VGND VGND VPWR VPWR sky130_fd_sc_hd__fill_2
XFILLER_1_30 VGND VGND VPWR VPWR sky130_fd_sc_hd__decap_3
XFILLER_1_63 VGND VGND VPWR VPWR sky130_fd_sc_hd__decap_3
XFILLER_52_116 VGND VGND VPWR VPWR sky130_fd_sc_hd__decap_3
XFILLER_37_179 VGND VGND VPWR VPWR sky130_fd_sc_hd__decap_3
XFILLER_25_308 VGND VGND VPWR VPWR sky130_fd_sc_hd__decap_3
XFILLER_52_127 VGND VGND VPWR VPWR sky130_fd_sc_hd__decap_3
X_1976_ _1976_/A _1976_/B VGND VGND VPWR VPWR _1977_/B sky130_fd_sc_hd__xnor2_1
XTAP_TAPCELL_ROW_43_391 VGND VPWR sky130_fd_sc_hd__tapvpwrvgnd_1
XFILLER_60_193 VGND VGND VPWR VPWR sky130_fd_sc_hd__decap_3
X_2528_ _2529_/A _2529_/B VGND VGND VPWR VPWR _2593_/A sky130_fd_sc_hd__nor2_2
X_2459_ _2459_/A _2498_/A VGND VGND VPWR VPWR _2460_/B sky130_fd_sc_hd__or2_1
XFILLER_29_48 VGND VGND VPWR VPWR sky130_fd_sc_hd__decap_3
XFILLER_43_105 VGND VGND VPWR VPWR sky130_fd_sc_hd__decap_3
XFILLER_43_127 VGND VGND VPWR VPWR sky130_fd_sc_hd__decap_3
XFILLER_3_234 VGND VGND VPWR VPWR sky130_fd_sc_hd__decap_3
XFILLER_3_223 VGND VGND VPWR VPWR sky130_fd_sc_hd__fill_1
XFILLER_3_267 VGND VGND VPWR VPWR sky130_fd_sc_hd__decap_3
XFILLER_19_113 VGND VGND VPWR VPWR sky130_fd_sc_hd__decap_3
XFILLER_59_293 VGND VGND VPWR VPWR sky130_fd_sc_hd__decap_3
XFILLER_19_81 VGND VGND VPWR VPWR sky130_fd_sc_hd__decap_3
XFILLER_19_135 VGND VGND VPWR VPWR sky130_fd_sc_hd__fill_1
XFILLER_19_157 VGND VGND VPWR VPWR sky130_fd_sc_hd__decap_3
XTAP_TAPCELL_ROW_57_472 VGND VPWR sky130_fd_sc_hd__tapvpwrvgnd_1
XFILLER_27_190 VGND VGND VPWR VPWR sky130_fd_sc_hd__fill_2
XFILLER_15_330 VGND VGND VPWR VPWR sky130_fd_sc_hd__fill_1
XFILLER_42_160 VGND VGND VPWR VPWR sky130_fd_sc_hd__decap_3
XFILLER_35_80 VGND VGND VPWR VPWR sky130_fd_sc_hd__decap_3
X_1830_ _1831_/B _1831_/A VGND VGND VPWR VPWR _1856_/A sky130_fd_sc_hd__nand2b_1
XFILLER_42_193 VGND VGND VPWR VPWR sky130_fd_sc_hd__decap_3
XFILLER_30_355 VGND VGND VPWR VPWR sky130_fd_sc_hd__decap_3
XFILLER_30_333 VGND VGND VPWR VPWR sky130_fd_sc_hd__decap_3
X_1761_ _1762_/B _1762_/C _1774_/A VGND VGND VPWR VPWR _1763_/A sky130_fd_sc_hd__a21o_1
XTAP_TAPCELL_ROW_40_372 VGND VPWR sky130_fd_sc_hd__tapvpwrvgnd_1
X_1692_ _1692_/A _1692_/B _1692_/C VGND VGND VPWR VPWR _1693_/C sky130_fd_sc_hd__or3_1
X_2313_ _2754_/A _2336_/B _1899_/B VGND VGND VPWR VPWR _2315_/B sky130_fd_sc_hd__a21oi_1
X_2244_ _2244_/A _2245_/B VGND VGND VPWR VPWR _2244_/X sky130_fd_sc_hd__and2_1
X_2175_ _2175_/A _2228_/A VGND VGND VPWR VPWR _2181_/A sky130_fd_sc_hd__nand2_1
XFILLER_25_149 VGND VGND VPWR VPWR sky130_fd_sc_hd__decap_3
XFILLER_25_116 VGND VGND VPWR VPWR sky130_fd_sc_hd__decap_3
XFILLER_33_193 VGND VGND VPWR VPWR sky130_fd_sc_hd__decap_3
X_1959_ _2284_/A _1949_/B _1949_/A VGND VGND VPWR VPWR _1962_/A sky130_fd_sc_hd__o21ba_1
XFILLER_56_35 VGND VGND VPWR VPWR sky130_fd_sc_hd__decap_3
XFILLER_56_24 VGND VGND VPWR VPWR sky130_fd_sc_hd__decap_3
XTAP_TAPCELL_ROW_46_409 VGND VPWR sky130_fd_sc_hd__tapvpwrvgnd_1
XFILLER_56_274 VGND VGND VPWR VPWR sky130_fd_sc_hd__decap_3
XTAP_TAPCELL_ROW_54_453 VGND VPWR sky130_fd_sc_hd__tapvpwrvgnd_1
XFILLER_12_333 VGND VGND VPWR VPWR sky130_fd_sc_hd__decap_3
XFILLER_24_193 VGND VGND VPWR VPWR sky130_fd_sc_hd__decap_3
XFILLER_8_337 VGND VGND VPWR VPWR sky130_fd_sc_hd__decap_3
XFILLER_8_315 VGND VGND VPWR VPWR sky130_fd_sc_hd__decap_3
XFILLER_21_93 VGND VGND VPWR VPWR sky130_fd_sc_hd__decap_3
XFILLER_47_274 VGND VGND VPWR VPWR sky130_fd_sc_hd__fill_1
XFILLER_47_241 VGND VGND VPWR VPWR sky130_fd_sc_hd__decap_3
XFILLER_22_119 VGND VGND VPWR VPWR sky130_fd_sc_hd__decap_3
Xclkbuf_0_clk clk VGND VGND VPWR VPWR clkbuf_0_clk/X sky130_fd_sc_hd__clkbuf_16
XFILLER_15_193 VGND VGND VPWR VPWR sky130_fd_sc_hd__decap_3
XTAP_TAPCELL_ROW_60_489 VGND VPWR sky130_fd_sc_hd__tapvpwrvgnd_1
XFILLER_30_163 VGND VGND VPWR VPWR sky130_fd_sc_hd__decap_3
XFILLER_30_141 VGND VGND VPWR VPWR sky130_fd_sc_hd__decap_3
X_1813_ _1813_/A _1813_/B VGND VGND VPWR VPWR _1815_/B sky130_fd_sc_hd__xnor2_1
X_1744_ _2003_/A _1524_/B _1506_/X VGND VGND VPWR VPWR _1775_/A sky130_fd_sc_hd__o21ba_1
XFILLER_7_84 VGND VGND VPWR VPWR sky130_fd_sc_hd__decap_3
X_1675_ _1675_/A _1675_/B _1675_/C VGND VGND VPWR VPWR _1676_/B sky130_fd_sc_hd__or3_1
XPHY_EDGE_ROW_15_Right_15 VGND VGND VPWR VPWR sky130_fd_sc_hd__decap_3
X_2227_ _2227_/A _2227_/B VGND VGND VPWR VPWR _2228_/B sky130_fd_sc_hd__or2_1
X_2158_ _2089_/Y _2091_/X _2286_/B _2149_/B VGND VGND VPWR VPWR _2159_/B sky130_fd_sc_hd__a211o_1
XFILLER_53_200 VGND VGND VPWR VPWR sky130_fd_sc_hd__decap_3
X_2089_ _2765_/Q _2742_/A _2335_/B VGND VGND VPWR VPWR _2089_/Y sky130_fd_sc_hd__nand3_1
XPHY_EDGE_ROW_24_Right_24 VGND VGND VPWR VPWR sky130_fd_sc_hd__decap_3
XFILLER_13_108 VGND VGND VPWR VPWR sky130_fd_sc_hd__decap_3
XFILLER_53_299 VGND VGND VPWR VPWR sky130_fd_sc_hd__decap_3
XTAP_TAPCELL_ROW_51_434 VGND VPWR sky130_fd_sc_hd__tapvpwrvgnd_1
XFILLER_42_15 VGND VGND VPWR VPWR sky130_fd_sc_hd__decap_3
XFILLER_42_48 VGND VGND VPWR VPWR sky130_fd_sc_hd__fill_1
XFILLER_21_141 VGND VGND VPWR VPWR sky130_fd_sc_hd__decap_3
XFILLER_21_196 VGND VGND VPWR VPWR sky130_fd_sc_hd__decap_3
XPHY_EDGE_ROW_33_Right_33 VGND VGND VPWR VPWR sky130_fd_sc_hd__decap_3
XTAP_TAPCELL_ROW_8_178 VGND VPWR sky130_fd_sc_hd__tapvpwrvgnd_1
XFILLER_29_252 VGND VGND VPWR VPWR sky130_fd_sc_hd__decap_3
XPHY_EDGE_ROW_42_Right_42 VGND VGND VPWR VPWR sky130_fd_sc_hd__decap_3
XFILLER_44_222 VGND VGND VPWR VPWR sky130_fd_sc_hd__decap_3
XFILLER_44_200 VGND VGND VPWR VPWR sky130_fd_sc_hd__fill_1
XFILLER_44_233 VGND VGND VPWR VPWR sky130_fd_sc_hd__decap_3
XFILLER_44_299 VGND VGND VPWR VPWR sky130_fd_sc_hd__decap_3
XFILLER_44_288 VGND VGND VPWR VPWR sky130_fd_sc_hd__fill_1
XFILLER_16_71 VGND VGND VPWR VPWR sky130_fd_sc_hd__decap_3
XFILLER_12_130 VGND VGND VPWR VPWR sky130_fd_sc_hd__fill_1
XFILLER_12_174 VGND VGND VPWR VPWR sky130_fd_sc_hd__decap_3
XPHY_EDGE_ROW_51_Right_51 VGND VGND VPWR VPWR sky130_fd_sc_hd__decap_3
XFILLER_32_81 VGND VGND VPWR VPWR sky130_fd_sc_hd__decap_3
XFILLER_8_189 VGND VGND VPWR VPWR sky130_fd_sc_hd__decap_3
XFILLER_4_351 VGND VGND VPWR VPWR sky130_fd_sc_hd__decap_3
X_1460_ _1460_/A _1460_/B VGND VGND VPWR VPWR _1462_/B sky130_fd_sc_hd__or2_1
X_1391_ _2765_/Q _1391_/B VGND VGND VPWR VPWR _1656_/A sky130_fd_sc_hd__xnor2_4
XPHY_EDGE_ROW_60_Right_60 VGND VGND VPWR VPWR sky130_fd_sc_hd__decap_3
X_2012_ _2012_/A1 _2009_/X _2008_/Y _1983_/Y VGND VGND VPWR VPWR _2013_/C sky130_fd_sc_hd__o211a_1
XFILLER_35_222 VGND VGND VPWR VPWR sky130_fd_sc_hd__fill_2
XFILLER_35_244 VGND VGND VPWR VPWR sky130_fd_sc_hd__decap_3
XFILLER_12_18 VGND VGND VPWR VPWR sky130_fd_sc_hd__decap_3
X_2776_ _2777_/CLK _2776_/D fanout48/X VGND VGND VPWR VPWR _2776_/Q sky130_fd_sc_hd__dfrtp_2
X_1727_ _1727_/A _1863_/A _1727_/C VGND VGND VPWR VPWR _1729_/B sky130_fd_sc_hd__or3_1
X_1658_ _2021_/A _2249_/B _1878_/A VGND VGND VPWR VPWR _1660_/B sky130_fd_sc_hd__a21o_1
X_1589_ _1588_/A _1588_/B _1606_/B _1573_/Y VGND VGND VPWR VPWR _1590_/B sky130_fd_sc_hd__o22a_1
XTAP_TAPCELL_ROW_5_159 VGND VPWR sky130_fd_sc_hd__tapvpwrvgnd_1
XFILLER_58_336 VGND VGND VPWR VPWR sky130_fd_sc_hd__decap_3
XFILLER_37_15 VGND VGND VPWR VPWR sky130_fd_sc_hd__decap_3
XFILLER_26_222 VGND VGND VPWR VPWR sky130_fd_sc_hd__fill_2
XFILLER_53_36 VGND VGND VPWR VPWR sky130_fd_sc_hd__decap_3
XFILLER_41_203 VGND VGND VPWR VPWR sky130_fd_sc_hd__decap_3
XFILLER_41_225 VGND VGND VPWR VPWR sky130_fd_sc_hd__fill_1
XFILLER_41_258 VGND VGND VPWR VPWR sky130_fd_sc_hd__decap_3
XFILLER_5_126 VGND VGND VPWR VPWR sky130_fd_sc_hd__fill_2
XFILLER_5_159 VGND VGND VPWR VPWR sky130_fd_sc_hd__decap_3
XFILLER_49_314 VGND VGND VPWR VPWR sky130_fd_sc_hd__decap_3
XFILLER_1_354 VGND VGND VPWR VPWR sky130_fd_sc_hd__decap_3
XFILLER_49_358 VGND VGND VPWR VPWR sky130_fd_sc_hd__decap_3
XFILLER_27_81 VGND VGND VPWR VPWR sky130_fd_sc_hd__decap_3
XFILLER_17_222 VGND VGND VPWR VPWR sky130_fd_sc_hd__fill_2
XFILLER_32_203 VGND VGND VPWR VPWR sky130_fd_sc_hd__decap_3
XFILLER_17_266 VGND VGND VPWR VPWR sky130_fd_sc_hd__decap_3
XTAP_TAPCELL_ROW_27_294 VGND VPWR sky130_fd_sc_hd__tapvpwrvgnd_1
X_2630_ _2630_/A _2630_/B VGND VGND VPWR VPWR _2631_/B sky130_fd_sc_hd__xnor2_1
X_2561_ _2564_/A _2614_/A VGND VGND VPWR VPWR _2577_/A sky130_fd_sc_hd__or2_1
X_1512_ _2206_/B _2045_/B _1511_/B VGND VGND VPWR VPWR _1512_/Y sky130_fd_sc_hd__o21ai_1
X_2492_ _2544_/A _2545_/A _2544_/B VGND VGND VPWR VPWR _2539_/B sky130_fd_sc_hd__o21bai_2
X_1443_ _2775_/Q _1451_/B _2729_/B _1442_/X VGND VGND VPWR VPWR _1456_/B sky130_fd_sc_hd__o31a_2
XFILLER_4_41 VGND VGND VPWR VPWR sky130_fd_sc_hd__decap_3
XFILLER_4_181 VGND VGND VPWR VPWR sky130_fd_sc_hd__decap_3
XFILLER_4_85 VGND VGND VPWR VPWR sky130_fd_sc_hd__decap_3
XFILLER_55_317 VGND VGND VPWR VPWR sky130_fd_sc_hd__decap_3
XFILLER_23_225 VGND VGND VPWR VPWR sky130_fd_sc_hd__fill_1
XFILLER_23_17 VGND VGND VPWR VPWR sky130_fd_sc_hd__decap_3
X_2759_ _2776_/Q _2759_/B VGND VGND VPWR VPWR _2760_/B sky130_fd_sc_hd__nor2_1
XFILLER_3_9 VGND VGND VPWR VPWR sky130_fd_sc_hd__decap_3
XFILLER_48_58 VGND VGND VPWR VPWR sky130_fd_sc_hd__decap_3
XFILLER_58_144 VGND VGND VPWR VPWR sky130_fd_sc_hd__decap_3
XFILLER_58_177 VGND VGND VPWR VPWR sky130_fd_sc_hd__decap_3
XFILLER_14_203 VGND VGND VPWR VPWR sky130_fd_sc_hd__decap_3
XFILLER_14_247 VGND VGND VPWR VPWR sky130_fd_sc_hd__decap_3
Xfanout40 _2466_/Y VGND VGND VPWR VPWR _2657_/B sky130_fd_sc_hd__dlymetal6s2s_1
XTAP_TAPCELL_ROW_24_275 VGND VPWR sky130_fd_sc_hd__tapvpwrvgnd_1
XFILLER_22_280 VGND VGND VPWR VPWR sky130_fd_sc_hd__decap_3
XFILLER_13_72 VGND VGND VPWR VPWR sky130_fd_sc_hd__decap_3
XFILLER_36_9 VGND VGND VPWR VPWR sky130_fd_sc_hd__decap_3
XFILLER_1_151 VGND VGND VPWR VPWR sky130_fd_sc_hd__fill_2
XFILLER_49_100 VGND VGND VPWR VPWR sky130_fd_sc_hd__decap_3
XFILLER_38_91 VGND VGND VPWR VPWR sky130_fd_sc_hd__decap_3
XFILLER_52_309 VGND VGND VPWR VPWR sky130_fd_sc_hd__decap_3
XTAP_TAPCELL_ROW_15_220 VGND VPWR sky130_fd_sc_hd__tapvpwrvgnd_1
X_1992_ _2050_/A _2050_/B VGND VGND VPWR VPWR _2054_/B sky130_fd_sc_hd__and2_1
XFILLER_20_217 VGND VGND VPWR VPWR sky130_fd_sc_hd__decap_3
XPHY_EDGE_ROW_41_Left_102 VGND VGND VPWR VPWR sky130_fd_sc_hd__decap_3
XFILLER_9_284 VGND VGND VPWR VPWR sky130_fd_sc_hd__decap_3
X_2613_ _2613_/A _2627_/A _2613_/C VGND VGND VPWR VPWR _2613_/Y sky130_fd_sc_hd__nor3_1
X_2544_ _2544_/A _2544_/B VGND VGND VPWR VPWR _2545_/B sky130_fd_sc_hd__nor2_1
X_2475_ _2475_/A _2478_/A VGND VGND VPWR VPWR _2476_/B sky130_fd_sc_hd__nand2_1
X_1426_ _2766_/Q _1427_/B VGND VGND VPWR VPWR _2284_/A sky130_fd_sc_hd__xnor2_4
XPHY_EDGE_ROW_50_Left_111 VGND VGND VPWR VPWR sky130_fd_sc_hd__decap_3
XFILLER_28_306 VGND VGND VPWR VPWR sky130_fd_sc_hd__fill_2
XFILLER_55_136 VGND VGND VPWR VPWR sky130_fd_sc_hd__decap_3
XTAP_TAPCELL_ROW_38_356 VGND VPWR sky130_fd_sc_hd__tapvpwrvgnd_1
XFILLER_55_169 VGND VGND VPWR VPWR sky130_fd_sc_hd__fill_2
XFILLER_43_309 VGND VGND VPWR VPWR sky130_fd_sc_hd__decap_3
XFILLER_51_320 VGND VGND VPWR VPWR sky130_fd_sc_hd__decap_3
XFILLER_34_27 VGND VGND VPWR VPWR sky130_fd_sc_hd__fill_1
XFILLER_11_217 VGND VGND VPWR VPWR sky130_fd_sc_hd__decap_3
XFILLER_11_228 VGND VGND VPWR VPWR sky130_fd_sc_hd__decap_3
XFILLER_50_15 VGND VGND VPWR VPWR sky130_fd_sc_hd__decap_3
XTAP_TAPCELL_ROW_21_256 VGND VPWR sky130_fd_sc_hd__tapvpwrvgnd_1
XFILLER_50_37 VGND VGND VPWR VPWR sky130_fd_sc_hd__decap_3
XFILLER_59_24 VGND VGND VPWR VPWR sky130_fd_sc_hd__decap_3
XFILLER_1_6 VGND VGND VPWR VPWR sky130_fd_sc_hd__decap_3
XFILLER_59_57 VGND VGND VPWR VPWR sky130_fd_sc_hd__decap_3
XFILLER_46_103 VGND VGND VPWR VPWR sky130_fd_sc_hd__decap_3
XFILLER_46_147 VGND VGND VPWR VPWR sky130_fd_sc_hd__decap_3
XFILLER_46_136 VGND VGND VPWR VPWR sky130_fd_sc_hd__decap_3
XFILLER_34_309 VGND VGND VPWR VPWR sky130_fd_sc_hd__decap_3
XFILLER_27_350 VGND VGND VPWR VPWR sky130_fd_sc_hd__decap_3
XFILLER_42_331 VGND VGND VPWR VPWR sky130_fd_sc_hd__decap_3
XTAP_TAPCELL_ROW_12_201 VGND VPWR sky130_fd_sc_hd__tapvpwrvgnd_1
XFILLER_24_60 VGND VGND VPWR VPWR sky130_fd_sc_hd__decap_3
XFILLER_10_250 VGND VGND VPWR VPWR sky130_fd_sc_hd__fill_2
X_2260_ _2259_/A _2259_/C _2259_/B VGND VGND VPWR VPWR _2271_/B sky130_fd_sc_hd__a21oi_1
XFILLER_34_6 VGND VGND VPWR VPWR sky130_fd_sc_hd__decap_3
X_2191_ _2123_/S _2191_/B VGND VGND VPWR VPWR _2243_/A sky130_fd_sc_hd__and2b_1
XFILLER_1_42 VGND VGND VPWR VPWR sky130_fd_sc_hd__decap_3
XFILLER_1_75 VGND VGND VPWR VPWR sky130_fd_sc_hd__decap_3
XFILLER_18_350 VGND VGND VPWR VPWR sky130_fd_sc_hd__decap_3
XFILLER_52_139 VGND VGND VPWR VPWR sky130_fd_sc_hd__fill_1
XFILLER_33_320 VGND VGND VPWR VPWR sky130_fd_sc_hd__decap_3
XFILLER_60_172 VGND VGND VPWR VPWR sky130_fd_sc_hd__decap_3
XFILLER_60_150 VGND VGND VPWR VPWR sky130_fd_sc_hd__decap_3
X_1975_ _1976_/A _1976_/B VGND VGND VPWR VPWR _1975_/X sky130_fd_sc_hd__or2_1
X_2527_ _2527_/A _2537_/A VGND VGND VPWR VPWR _2529_/B sky130_fd_sc_hd__xnor2_1
X_2458_ _2712_/A _2650_/B VGND VGND VPWR VPWR _2721_/A sky130_fd_sc_hd__nor2_1
X_1409_ _1473_/B _1442_/B hold1/A VGND VGND VPWR VPWR _1410_/B sky130_fd_sc_hd__or3b_1
X_2389_ _2673_/A _2478_/A VGND VGND VPWR VPWR _2390_/B sky130_fd_sc_hd__nor2_1
XFILLER_28_147 VGND VGND VPWR VPWR sky130_fd_sc_hd__decap_3
XFILLER_28_136 VGND VGND VPWR VPWR sky130_fd_sc_hd__decap_3
XFILLER_28_125 VGND VGND VPWR VPWR sky130_fd_sc_hd__decap_3
XFILLER_45_15 VGND VGND VPWR VPWR sky130_fd_sc_hd__decap_3
XFILLER_16_309 VGND VGND VPWR VPWR sky130_fd_sc_hd__fill_1
XFILLER_43_139 VGND VGND VPWR VPWR sky130_fd_sc_hd__fill_1
XPHY_EDGE_ROW_7_Left_68 VGND VGND VPWR VPWR sky130_fd_sc_hd__decap_3
XFILLER_3_202 VGND VGND VPWR VPWR sky130_fd_sc_hd__fill_1
XFILLER_10_73 VGND VGND VPWR VPWR sky130_fd_sc_hd__decap_3
XFILLER_10_95 VGND VGND VPWR VPWR sky130_fd_sc_hd__decap_3
XFILLER_3_279 VGND VGND VPWR VPWR sky130_fd_sc_hd__fill_1
XFILLER_59_261 VGND VGND VPWR VPWR sky130_fd_sc_hd__decap_3
XFILLER_19_125 VGND VGND VPWR VPWR sky130_fd_sc_hd__fill_1
XTAP_TAPCELL_ROW_57_473 VGND VPWR sky130_fd_sc_hd__tapvpwrvgnd_1
XFILLER_35_92 VGND VGND VPWR VPWR sky130_fd_sc_hd__fill_1
XFILLER_30_312 VGND VGND VPWR VPWR sky130_fd_sc_hd__decap_3
X_1760_ _1765_/B _1765_/A VGND VGND VPWR VPWR _1760_/Y sky130_fd_sc_hd__nand2b_1
XTAP_TAPCELL_ROW_40_373 VGND VPWR sky130_fd_sc_hd__tapvpwrvgnd_1
X_1691_ _1692_/A _1692_/C _1692_/B VGND VGND VPWR VPWR _1693_/B sky130_fd_sc_hd__o21ai_1
X_2312_ _2312_/A _2312_/B VGND VGND VPWR VPWR _2334_/A sky130_fd_sc_hd__xnor2_2
X_2243_ _2243_/A _2243_/B VGND VGND VPWR VPWR _2245_/B sky130_fd_sc_hd__xnor2_1
X_2174_ _2227_/A _2227_/B VGND VGND VPWR VPWR _2228_/A sky130_fd_sc_hd__nand2_1
XFILLER_25_106 VGND VGND VPWR VPWR sky130_fd_sc_hd__decap_3
XFILLER_25_128 VGND VGND VPWR VPWR sky130_fd_sc_hd__decap_3
XFILLER_15_18 VGND VGND VPWR VPWR sky130_fd_sc_hd__decap_3
XFILLER_33_172 VGND VGND VPWR VPWR sky130_fd_sc_hd__decap_3
XFILLER_21_312 VGND VGND VPWR VPWR sky130_fd_sc_hd__fill_1
XFILLER_21_356 VGND VGND VPWR VPWR sky130_fd_sc_hd__decap_3
X_1958_ _2026_/A _2026_/B _1949_/A VGND VGND VPWR VPWR _1963_/A sky130_fd_sc_hd__o21bai_1
X_1889_ _1960_/A _1889_/B VGND VGND VPWR VPWR _1890_/B sky130_fd_sc_hd__xor2_1
XFILLER_56_47 VGND VGND VPWR VPWR sky130_fd_sc_hd__decap_3
XFILLER_56_231 VGND VGND VPWR VPWR sky130_fd_sc_hd__fill_1
XFILLER_56_58 VGND VGND VPWR VPWR sky130_fd_sc_hd__fill_2
XFILLER_56_253 VGND VGND VPWR VPWR sky130_fd_sc_hd__decap_3
XFILLER_56_286 VGND VGND VPWR VPWR sky130_fd_sc_hd__decap_3
XTAP_TAPCELL_ROW_54_454 VGND VPWR sky130_fd_sc_hd__tapvpwrvgnd_1
XFILLER_24_172 VGND VGND VPWR VPWR sky130_fd_sc_hd__decap_3
XFILLER_8_349 VGND VGND VPWR VPWR sky130_fd_sc_hd__decap_3
XFILLER_21_72 VGND VGND VPWR VPWR sky130_fd_sc_hd__decap_3
XFILLER_39_209 VGND VGND VPWR VPWR sky130_fd_sc_hd__decap_3
XFILLER_47_220 VGND VGND VPWR VPWR sky130_fd_sc_hd__decap_3
XFILLER_47_264 VGND VGND VPWR VPWR sky130_fd_sc_hd__decap_3
XFILLER_47_297 VGND VGND VPWR VPWR sky130_fd_sc_hd__decap_3
XFILLER_46_91 VGND VGND VPWR VPWR sky130_fd_sc_hd__decap_3
XFILLER_22_109 VGND VGND VPWR VPWR sky130_fd_sc_hd__decap_3
XFILLER_30_120 VGND VGND VPWR VPWR sky130_fd_sc_hd__decap_3
X_1812_ _1886_/B _2284_/A VGND VGND VPWR VPWR _1813_/B sky130_fd_sc_hd__nor2_1
XFILLER_7_30 VGND VGND VPWR VPWR sky130_fd_sc_hd__decap_3
X_1743_ _1556_/Y _1742_/A _1743_/S VGND VGND VPWR VPWR _1743_/X sky130_fd_sc_hd__mux2_1
X_1674_ _1675_/A _1675_/B _1675_/C VGND VGND VPWR VPWR _1676_/A sky130_fd_sc_hd__o21ai_2
XFILLER_7_96 VGND VGND VPWR VPWR sky130_fd_sc_hd__decap_3
X_2226_ _2211_/A _2211_/B _2209_/Y VGND VGND VPWR VPWR _2230_/A sky130_fd_sc_hd__o21a_1
XFILLER_38_253 VGND VGND VPWR VPWR sky130_fd_sc_hd__decap_3
XFILLER_38_231 VGND VGND VPWR VPWR sky130_fd_sc_hd__decap_3
X_2157_ _2208_/A _2208_/B VGND VGND VPWR VPWR _2163_/A sky130_fd_sc_hd__and2_1
XFILLER_53_223 VGND VGND VPWR VPWR sky130_fd_sc_hd__fill_1
XFILLER_53_212 VGND VGND VPWR VPWR sky130_fd_sc_hd__fill_1
X_2088_ _2095_/B _2088_/B VGND VGND VPWR VPWR _2094_/A sky130_fd_sc_hd__xor2_1
XFILLER_53_267 VGND VGND VPWR VPWR sky130_fd_sc_hd__decap_3
XTAP_TAPCELL_ROW_51_435 VGND VPWR sky130_fd_sc_hd__tapvpwrvgnd_1
XFILLER_42_27 VGND VGND VPWR VPWR sky130_fd_sc_hd__fill_1
XTAP_TAPCELL_ROW_8_179 VGND VPWR sky130_fd_sc_hd__tapvpwrvgnd_1
XFILLER_29_231 VGND VGND VPWR VPWR sky130_fd_sc_hd__decap_3
XFILLER_44_267 VGND VGND VPWR VPWR sky130_fd_sc_hd__decap_3
XFILLER_16_50 VGND VGND VPWR VPWR sky130_fd_sc_hd__decap_3
XFILLER_16_94 VGND VGND VPWR VPWR sky130_fd_sc_hd__decap_3
XFILLER_12_186 VGND VGND VPWR VPWR sky130_fd_sc_hd__decap_3
XFILLER_8_124 VGND VGND VPWR VPWR sky130_fd_sc_hd__decap_3
XFILLER_8_168 VGND VGND VPWR VPWR sky130_fd_sc_hd__decap_3
XFILLER_8_157 VGND VGND VPWR VPWR sky130_fd_sc_hd__fill_2
XFILLER_4_341 VGND VGND VPWR VPWR sky130_fd_sc_hd__decap_3
X_1390_ _2765_/Q _1391_/B VGND VGND VPWR VPWR _2310_/B sky130_fd_sc_hd__xor2_4
X_2011_ _2011_/A _2011_/B VGND VGND VPWR VPWR _2013_/B sky130_fd_sc_hd__nor2_1
XFILLER_35_201 VGND VGND VPWR VPWR sky130_fd_sc_hd__decap_3
XFILLER_35_256 VGND VGND VPWR VPWR sky130_fd_sc_hd__decap_3
X_2775_ _2777_/CLK _2775_/D fanout48/X VGND VGND VPWR VPWR _2775_/Q sky130_fd_sc_hd__dfrtp_4
X_1726_ _1721_/A _1721_/B _1719_/X VGND VGND VPWR VPWR _1868_/A sky130_fd_sc_hd__a21oi_1
X_1657_ _2735_/A _2249_/B VGND VGND VPWR VPWR _2286_/A sky130_fd_sc_hd__nor2_2
X_1588_ _1588_/A _1588_/B VGND VGND VPWR VPWR _1606_/B sky130_fd_sc_hd__xnor2_1
XFILLER_58_315 VGND VGND VPWR VPWR sky130_fd_sc_hd__decap_3
XFILLER_58_304 VGND VGND VPWR VPWR sky130_fd_sc_hd__decap_3
XFILLER_58_348 VGND VGND VPWR VPWR sky130_fd_sc_hd__decap_3
XFILLER_37_49 VGND VGND VPWR VPWR sky130_fd_sc_hd__decap_3
X_2209_ _2210_/A _2210_/B VGND VGND VPWR VPWR _2209_/Y sky130_fd_sc_hd__nand2_1
XFILLER_53_15 VGND VGND VPWR VPWR sky130_fd_sc_hd__decap_3
XFILLER_26_278 VGND VGND VPWR VPWR sky130_fd_sc_hd__decap_3
XFILLER_26_256 VGND VGND VPWR VPWR sky130_fd_sc_hd__decap_3
XFILLER_41_237 VGND VGND VPWR VPWR sky130_fd_sc_hd__decap_3
XFILLER_5_105 VGND VGND VPWR VPWR sky130_fd_sc_hd__decap_3
XPHY_EDGE_ROW_36_Left_97 VGND VGND VPWR VPWR sky130_fd_sc_hd__decap_3
XFILLER_49_337 VGND VGND VPWR VPWR sky130_fd_sc_hd__decap_3
XFILLER_49_326 VGND VGND VPWR VPWR sky130_fd_sc_hd__decap_3
XFILLER_17_201 VGND VGND VPWR VPWR sky130_fd_sc_hd__decap_3
XFILLER_27_60 VGND VGND VPWR VPWR sky130_fd_sc_hd__decap_3
XFILLER_17_234 VGND VGND VPWR VPWR sky130_fd_sc_hd__decap_3
XTAP_TAPCELL_ROW_27_295 VGND VPWR sky130_fd_sc_hd__tapvpwrvgnd_1
XFILLER_32_259 VGND VGND VPWR VPWR sky130_fd_sc_hd__decap_3
XFILLER_40_281 VGND VGND VPWR VPWR sky130_fd_sc_hd__decap_3
X_2560_ _2560_/A _2560_/B VGND VGND VPWR VPWR _2614_/A sky130_fd_sc_hd__xor2_2
X_1511_ _2206_/B _1511_/B VGND VGND VPWR VPWR _1703_/B sky130_fd_sc_hd__or2_1
X_2491_ _2550_/A _2489_/Y _2479_/Y VGND VGND VPWR VPWR _2545_/A sky130_fd_sc_hd__a21o_1
X_1442_ _2776_/Q _1442_/B _1473_/B VGND VGND VPWR VPWR _1442_/X sky130_fd_sc_hd__or3b_1
XFILLER_4_193 VGND VGND VPWR VPWR sky130_fd_sc_hd__decap_3
XFILLER_4_75 VGND VGND VPWR VPWR sky130_fd_sc_hd__decap_3
XFILLER_4_97 VGND VGND VPWR VPWR sky130_fd_sc_hd__decap_3
XFILLER_55_329 VGND VGND VPWR VPWR sky130_fd_sc_hd__decap_3
XTAP_TAPCELL_ROW_18_240 VGND VPWR sky130_fd_sc_hd__tapvpwrvgnd_1
X_2758_ _2759_/B _2758_/B VGND VGND VPWR VPWR _2775_/D sky130_fd_sc_hd__nor2_1
X_1709_ _1713_/A _1709_/B VGND VGND VPWR VPWR _1849_/B sky130_fd_sc_hd__and2_1
X_2689_ _2672_/X _2686_/X _2688_/X _2696_/A VGND VGND VPWR VPWR _2690_/B sky130_fd_sc_hd__o31a_2
XFILLER_48_15 VGND VGND VPWR VPWR sky130_fd_sc_hd__decap_3
XFILLER_46_307 VGND VGND VPWR VPWR sky130_fd_sc_hd__fill_1
XFILLER_54_351 VGND VGND VPWR VPWR sky130_fd_sc_hd__decap_3
XFILLER_14_226 VGND VGND VPWR VPWR sky130_fd_sc_hd__decap_3
XFILLER_14_215 VGND VGND VPWR VPWR sky130_fd_sc_hd__decap_3
Xfanout30 _1999_/A VGND VGND VPWR VPWR _1878_/A sky130_fd_sc_hd__clkbuf_2
XFILLER_14_259 VGND VGND VPWR VPWR sky130_fd_sc_hd__decap_3
Xfanout41 _2662_/A VGND VGND VPWR VPWR _1438_/B sky130_fd_sc_hd__buf_4
XTAP_TAPCELL_ROW_24_276 VGND VPWR sky130_fd_sc_hd__tapvpwrvgnd_1
XFILLER_13_51 VGND VGND VPWR VPWR sky130_fd_sc_hd__decap_3
XFILLER_22_292 VGND VGND VPWR VPWR sky130_fd_sc_hd__decap_3
XFILLER_13_84 VGND VGND VPWR VPWR sky130_fd_sc_hd__decap_3
XFILLER_49_123 VGND VGND VPWR VPWR sky130_fd_sc_hd__decap_3
XFILLER_49_167 VGND VGND VPWR VPWR sky130_fd_sc_hd__fill_1
XFILLER_37_318 VGND VGND VPWR VPWR sky130_fd_sc_hd__decap_3
XFILLER_45_351 VGND VGND VPWR VPWR sky130_fd_sc_hd__decap_3
XFILLER_60_321 VGND VGND VPWR VPWR sky130_fd_sc_hd__decap_3
XTAP_TAPCELL_ROW_15_221 VGND VPWR sky130_fd_sc_hd__tapvpwrvgnd_1
XFILLER_60_343 VGND VGND VPWR VPWR sky130_fd_sc_hd__decap_3
XFILLER_54_91 VGND VGND VPWR VPWR sky130_fd_sc_hd__decap_3
XFILLER_13_270 VGND VGND VPWR VPWR sky130_fd_sc_hd__decap_3
X_1991_ _2206_/B _1495_/Y _1916_/Y _2217_/B VGND VGND VPWR VPWR _2050_/B sky130_fd_sc_hd__o22a_1
XFILLER_9_252 VGND VGND VPWR VPWR sky130_fd_sc_hd__decap_3
XFILLER_9_241 VGND VGND VPWR VPWR sky130_fd_sc_hd__fill_1
XFILLER_9_230 VGND VGND VPWR VPWR sky130_fd_sc_hd__decap_3
X_2612_ _2612_/A VGND VGND VPWR VPWR _2613_/C sky130_fd_sc_hd__inv_2
XFILLER_9_296 VGND VGND VPWR VPWR sky130_fd_sc_hd__fill_2
X_2543_ _2543_/A _2554_/A VGND VGND VPWR VPWR _2548_/A sky130_fd_sc_hd__xor2_1
X_2474_ _2475_/A _2478_/A VGND VGND VPWR VPWR _2474_/Y sky130_fd_sc_hd__nor2_1
X_1425_ _1886_/B _1425_/B VGND VGND VPWR VPWR _1434_/B sky130_fd_sc_hd__nor2_1
XFILLER_18_18 VGND VGND VPWR VPWR sky130_fd_sc_hd__decap_3
XTAP_TAPCELL_ROW_38_357 VGND VPWR sky130_fd_sc_hd__tapvpwrvgnd_1
XFILLER_36_340 VGND VGND VPWR VPWR sky130_fd_sc_hd__decap_3
XFILLER_51_343 VGND VGND VPWR VPWR sky130_fd_sc_hd__decap_3
XFILLER_51_332 VGND VGND VPWR VPWR sky130_fd_sc_hd__decap_3
XFILLER_34_39 VGND VGND VPWR VPWR sky130_fd_sc_hd__decap_3
XTAP_TAPCELL_ROW_21_257 VGND VPWR sky130_fd_sc_hd__tapvpwrvgnd_1
XFILLER_50_49 VGND VGND VPWR VPWR sky130_fd_sc_hd__decap_3
XFILLER_50_27 VGND VGND VPWR VPWR sky130_fd_sc_hd__fill_1
XFILLER_59_36 VGND VGND VPWR VPWR sky130_fd_sc_hd__decap_3
XFILLER_59_69 VGND VGND VPWR VPWR sky130_fd_sc_hd__decap_3
XTAP_TAPCELL_ROW_29_302 VGND VPWR sky130_fd_sc_hd__tapvpwrvgnd_1
XFILLER_46_115 VGND VGND VPWR VPWR sky130_fd_sc_hd__fill_2
XFILLER_46_159 VGND VGND VPWR VPWR sky130_fd_sc_hd__decap_3
XFILLER_27_340 VGND VGND VPWR VPWR sky130_fd_sc_hd__fill_1
XFILLER_54_181 VGND VGND VPWR VPWR sky130_fd_sc_hd__decap_3
XTAP_TAPCELL_ROW_12_202 VGND VPWR sky130_fd_sc_hd__tapvpwrvgnd_1
XFILLER_24_94 VGND VGND VPWR VPWR sky130_fd_sc_hd__decap_3
XFILLER_24_72 VGND VGND VPWR VPWR sky130_fd_sc_hd__decap_3
XFILLER_10_262 VGND VGND VPWR VPWR sky130_fd_sc_hd__fill_1
XFILLER_40_71 VGND VGND VPWR VPWR sky130_fd_sc_hd__decap_3
XFILLER_6_288 VGND VGND VPWR VPWR sky130_fd_sc_hd__decap_3
X_2190_ _2192_/A _2192_/B VGND VGND VPWR VPWR _2195_/B sky130_fd_sc_hd__and2b_1
XFILLER_27_6 VGND VGND VPWR VPWR sky130_fd_sc_hd__decap_3
XFILLER_1_21 VGND VGND VPWR VPWR sky130_fd_sc_hd__decap_3
XFILLER_37_148 VGND VGND VPWR VPWR sky130_fd_sc_hd__fill_2
XFILLER_1_54 VGND VGND VPWR VPWR sky130_fd_sc_hd__fill_2
XFILLER_52_107 VGND VGND VPWR VPWR sky130_fd_sc_hd__decap_3
XFILLER_1_98 VGND VGND VPWR VPWR sky130_fd_sc_hd__fill_2
XFILLER_1_87 VGND VGND VPWR VPWR sky130_fd_sc_hd__decap_3
XTAP_TAPCELL_ROW_35_338 VGND VPWR sky130_fd_sc_hd__tapvpwrvgnd_1
XFILLER_33_354 VGND VGND VPWR VPWR sky130_fd_sc_hd__decap_3
XFILLER_33_332 VGND VGND VPWR VPWR sky130_fd_sc_hd__decap_3
XPHY_EDGE_ROW_23_Left_84 VGND VGND VPWR VPWR sky130_fd_sc_hd__decap_3
XFILLER_60_162 VGND VGND VPWR VPWR sky130_fd_sc_hd__decap_3
X_1974_ _1963_/A _1963_/B _1961_/Y VGND VGND VPWR VPWR _1977_/A sky130_fd_sc_hd__a21o_1
XFILLER_60_184 VGND VGND VPWR VPWR sky130_fd_sc_hd__decap_3
X_2526_ _2532_/A _2541_/A VGND VGND VPWR VPWR _2529_/A sky130_fd_sc_hd__nand2b_1
X_2457_ _2457_/A _2457_/B VGND VGND VPWR VPWR _2650_/B sky130_fd_sc_hd__nand2_1
X_1408_ _1586_/A _1408_/B _1408_/C VGND VGND VPWR VPWR _1813_/A sky130_fd_sc_hd__and3_4
XFILLER_29_39 VGND VGND VPWR VPWR sky130_fd_sc_hd__decap_3
X_2388_ _2673_/A _2478_/A VGND VGND VPWR VPWR _2455_/B sky130_fd_sc_hd__and2_1
XFILLER_45_27 VGND VGND VPWR VPWR sky130_fd_sc_hd__decap_3
XFILLER_45_49 VGND VGND VPWR VPWR sky130_fd_sc_hd__decap_3
XFILLER_3_225 VGND VGND VPWR VPWR sky130_fd_sc_hd__decap_3
XFILLER_59_240 VGND VGND VPWR VPWR sky130_fd_sc_hd__decap_3
XFILLER_59_273 VGND VGND VPWR VPWR sky130_fd_sc_hd__decap_3
XFILLER_59_284 VGND VGND VPWR VPWR sky130_fd_sc_hd__decap_3
XFILLER_19_72 VGND VGND VPWR VPWR sky130_fd_sc_hd__fill_2
XTAP_TAPCELL_ROW_57_474 VGND VPWR sky130_fd_sc_hd__tapvpwrvgnd_1
XFILLER_27_181 VGND VGND VPWR VPWR sky130_fd_sc_hd__decap_3
XFILLER_15_321 VGND VGND VPWR VPWR sky130_fd_sc_hd__decap_3
XFILLER_42_151 VGND VGND VPWR VPWR sky130_fd_sc_hd__fill_2
XFILLER_30_346 VGND VGND VPWR VPWR sky130_fd_sc_hd__decap_3
X_1690_ _1693_/A _1690_/B _1690_/C VGND VGND VPWR VPWR _1692_/C sky130_fd_sc_hd__and3_1
XFILLER_51_92 VGND VGND VPWR VPWR sky130_fd_sc_hd__decap_3
X_2311_ _2312_/A _2312_/B VGND VGND VPWR VPWR _2311_/Y sky130_fd_sc_hd__nand2_1
X_2242_ _2244_/A VGND VGND VPWR VPWR _2245_/A sky130_fd_sc_hd__inv_2
XFILLER_25_3 VGND VGND VPWR VPWR sky130_fd_sc_hd__decap_3
X_2173_ _2261_/B _2173_/B VGND VGND VPWR VPWR _2227_/B sky130_fd_sc_hd__xnor2_1
XFILLER_18_192 VGND VGND VPWR VPWR sky130_fd_sc_hd__decap_3
XFILLER_33_184 VGND VGND VPWR VPWR sky130_fd_sc_hd__fill_1
XFILLER_21_335 VGND VGND VPWR VPWR sky130_fd_sc_hd__fill_1
X_1957_ _1957_/A _1957_/B VGND VGND VPWR VPWR _2029_/A sky130_fd_sc_hd__xor2_1
X_1888_ _1960_/A _1960_/B _1886_/X VGND VGND VPWR VPWR _1892_/A sky130_fd_sc_hd__o21ai_1
XFILLER_0_206 VGND VGND VPWR VPWR sky130_fd_sc_hd__fill_2
XFILLER_0_217 VGND VGND VPWR VPWR sky130_fd_sc_hd__decap_3
XFILLER_0_228 VGND VGND VPWR VPWR sky130_fd_sc_hd__fill_2
X_2509_ _2643_/A _2527_/A VGND VGND VPWR VPWR _2509_/X sky130_fd_sc_hd__or2_1
XFILLER_56_15 VGND VGND VPWR VPWR sky130_fd_sc_hd__decap_3
XFILLER_56_265 VGND VGND VPWR VPWR sky130_fd_sc_hd__decap_3
XFILLER_56_298 VGND VGND VPWR VPWR sky130_fd_sc_hd__decap_3
XFILLER_12_302 VGND VGND VPWR VPWR sky130_fd_sc_hd__decap_3
XTAP_TAPCELL_ROW_54_455 VGND VPWR sky130_fd_sc_hd__tapvpwrvgnd_1
XFILLER_12_324 VGND VGND VPWR VPWR sky130_fd_sc_hd__decap_3
XFILLER_24_184 VGND VGND VPWR VPWR sky130_fd_sc_hd__decap_3
XFILLER_8_328 VGND VGND VPWR VPWR sky130_fd_sc_hd__decap_3
XFILLER_21_84 VGND VGND VPWR VPWR sky130_fd_sc_hd__decap_3
XTAP_TAPCELL_ROW_45_400 VGND VPWR sky130_fd_sc_hd__tapvpwrvgnd_1
XFILLER_30_110 VGND VGND VPWR VPWR sky130_fd_sc_hd__decap_3
X_1811_ _1960_/A _1889_/B _1809_/X VGND VGND VPWR VPWR _1815_/A sky130_fd_sc_hd__o21ai_1
X_1742_ _1742_/A _1742_/B VGND VGND VPWR VPWR _1752_/B sky130_fd_sc_hd__xnor2_1
XFILLER_7_42 VGND VGND VPWR VPWR sky130_fd_sc_hd__decap_3
X_1673_ _1673_/A _1673_/B VGND VGND VPWR VPWR _1675_/C sky130_fd_sc_hd__xor2_1
X_2225_ _2267_/A _2328_/A _2224_/B _2220_/Y VGND VGND VPWR VPWR _2232_/A sky130_fd_sc_hd__o31a_1
XFILLER_38_210 VGND VGND VPWR VPWR sky130_fd_sc_hd__decap_3
XFILLER_38_243 VGND VGND VPWR VPWR sky130_fd_sc_hd__decap_3
X_2156_ _2206_/B _2222_/A _2116_/C _2115_/X _2155_/Y VGND VGND VPWR VPWR _2208_/B
+ sky130_fd_sc_hd__o32a_1
XFILLER_38_276 VGND VGND VPWR VPWR sky130_fd_sc_hd__decap_3
XFILLER_26_29 VGND VGND VPWR VPWR sky130_fd_sc_hd__fill_2
X_2087_ _2095_/B _2088_/B VGND VGND VPWR VPWR _2104_/A sky130_fd_sc_hd__nor2_1
XPHY_EDGE_ROW_5_Right_5 VGND VGND VPWR VPWR sky130_fd_sc_hd__decap_3
XFILLER_53_279 VGND VGND VPWR VPWR sky130_fd_sc_hd__fill_1
XTAP_TAPCELL_ROW_51_436 VGND VPWR sky130_fd_sc_hd__tapvpwrvgnd_1
XFILLER_42_39 VGND VGND VPWR VPWR sky130_fd_sc_hd__decap_3
XFILLER_21_165 VGND VGND VPWR VPWR sky130_fd_sc_hd__decap_3
XPHY_EDGE_ROW_10_Left_71 VGND VGND VPWR VPWR sky130_fd_sc_hd__decap_3
XFILLER_29_243 VGND VGND VPWR VPWR sky130_fd_sc_hd__decap_3
XFILLER_29_287 VGND VGND VPWR VPWR sky130_fd_sc_hd__decap_3
XFILLER_29_276 VGND VGND VPWR VPWR sky130_fd_sc_hd__decap_3
XFILLER_44_279 VGND VGND VPWR VPWR sky130_fd_sc_hd__decap_3
XFILLER_16_62 VGND VGND VPWR VPWR sky130_fd_sc_hd__decap_3
XFILLER_8_103 VGND VGND VPWR VPWR sky130_fd_sc_hd__decap_3
XFILLER_8_136 VGND VGND VPWR VPWR sky130_fd_sc_hd__decap_3
XFILLER_32_72 VGND VGND VPWR VPWR sky130_fd_sc_hd__decap_3
XFILLER_59_9 VGND VGND VPWR VPWR sky130_fd_sc_hd__decap_3
X_2010_ _1983_/Y _2008_/Y _2009_/X _2012_/A1 VGND VGND VPWR VPWR _2077_/A sky130_fd_sc_hd__a211oi_2
XFILLER_57_80 VGND VGND VPWR VPWR sky130_fd_sc_hd__decap_3
XFILLER_35_213 VGND VGND VPWR VPWR sky130_fd_sc_hd__decap_3
XFILLER_35_235 VGND VGND VPWR VPWR sky130_fd_sc_hd__decap_3
XFILLER_35_268 VGND VGND VPWR VPWR sky130_fd_sc_hd__decap_3
XFILLER_50_216 VGND VGND VPWR VPWR sky130_fd_sc_hd__decap_3
X_2774_ _2777_/CLK _2774_/D fanout48/X VGND VGND VPWR VPWR _2774_/Q sky130_fd_sc_hd__dfrtp_4
X_1725_ _1727_/A _1863_/A _1727_/C VGND VGND VPWR VPWR _1729_/A sky130_fd_sc_hd__o21ai_1
X_1656_ _1656_/A _1886_/A VGND VGND VPWR VPWR _1801_/A sky130_fd_sc_hd__nor2_1
X_1587_ _1587_/A _1587_/B VGND VGND VPWR VPWR _1588_/B sky130_fd_sc_hd__xnor2_1
XFILLER_58_327 VGND VGND VPWR VPWR sky130_fd_sc_hd__decap_3
XFILLER_37_39 VGND VGND VPWR VPWR sky130_fd_sc_hd__decap_3
X_2208_ _2208_/A _2208_/B VGND VGND VPWR VPWR _2210_/B sky130_fd_sc_hd__xor2_1
XFILLER_26_213 VGND VGND VPWR VPWR sky130_fd_sc_hd__decap_3
X_2139_ _2140_/A _2140_/B VGND VGND VPWR VPWR _2139_/Y sky130_fd_sc_hd__nand2_1
XFILLER_53_27 VGND VGND VPWR VPWR sky130_fd_sc_hd__decap_3
XFILLER_53_49 VGND VGND VPWR VPWR sky130_fd_sc_hd__decap_3
XFILLER_41_249 VGND VGND VPWR VPWR sky130_fd_sc_hd__decap_3
XFILLER_49_305 VGND VGND VPWR VPWR sky130_fd_sc_hd__decap_3
XFILLER_1_345 VGND VGND VPWR VPWR sky130_fd_sc_hd__decap_3
XFILLER_49_349 VGND VGND VPWR VPWR sky130_fd_sc_hd__decap_3
XFILLER_27_72 VGND VGND VPWR VPWR sky130_fd_sc_hd__decap_3
XFILLER_17_246 VGND VGND VPWR VPWR sky130_fd_sc_hd__decap_3
XFILLER_17_213 VGND VGND VPWR VPWR sky130_fd_sc_hd__decap_3
XFILLER_17_279 VGND VGND VPWR VPWR sky130_fd_sc_hd__fill_1
XFILLER_17_257 VGND VGND VPWR VPWR sky130_fd_sc_hd__decap_3
XFILLER_32_249 VGND VGND VPWR VPWR sky130_fd_sc_hd__decap_3
XFILLER_43_93 VGND VGND VPWR VPWR sky130_fd_sc_hd__decap_3
X_1510_ _1521_/A _1642_/A _1521_/C VGND VGND VPWR VPWR _1653_/A sky130_fd_sc_hd__o21a_1
X_2490_ _2490_/A _2490_/B VGND VGND VPWR VPWR _2550_/B sky130_fd_sc_hd__xnor2_1
XFILLER_57_6 VGND VGND VPWR VPWR sky130_fd_sc_hd__decap_3
XFILLER_4_150 VGND VGND VPWR VPWR sky130_fd_sc_hd__fill_2
X_1441_ _1441_/A _1441_/B VGND VGND VPWR VPWR _1465_/A sky130_fd_sc_hd__nand2_2
XFILLER_4_32 VGND VGND VPWR VPWR sky130_fd_sc_hd__decap_3
XFILLER_4_21 VGND VGND VPWR VPWR sky130_fd_sc_hd__decap_3
XFILLER_4_172 VGND VGND VPWR VPWR sky130_fd_sc_hd__fill_1
XFILLER_55_308 VGND VGND VPWR VPWR sky130_fd_sc_hd__decap_3
XFILLER_48_360 VGND VGND VPWR VPWR sky130_fd_sc_hd__fill_1
XTAP_TAPCELL_ROW_18_241 VGND VPWR sky130_fd_sc_hd__tapvpwrvgnd_1
XFILLER_16_290 VGND VGND VPWR VPWR sky130_fd_sc_hd__fill_2
XFILLER_31_260 VGND VGND VPWR VPWR sky130_fd_sc_hd__decap_3
X_2757_ _2775_/Q _2757_/B VGND VGND VPWR VPWR _2758_/B sky130_fd_sc_hd__nor2_1
X_1708_ _2206_/B _2222_/A _1511_/B VGND VGND VPWR VPWR _1709_/B sky130_fd_sc_hd__o21ai_1
X_2688_ _2437_/B _2669_/Y _2687_/Y _1489_/B VGND VGND VPWR VPWR _2688_/X sky130_fd_sc_hd__a2bb2o_1
X_1639_ _1640_/A _1640_/B _1640_/C VGND VGND VPWR VPWR _1644_/A sky130_fd_sc_hd__o21a_1
XFILLER_48_38 VGND VGND VPWR VPWR sky130_fd_sc_hd__decap_3
XFILLER_48_27 VGND VGND VPWR VPWR sky130_fd_sc_hd__fill_1
XFILLER_58_168 VGND VGND VPWR VPWR sky130_fd_sc_hd__decap_3
XFILLER_54_330 VGND VGND VPWR VPWR sky130_fd_sc_hd__decap_3
Xfanout20 _1495_/Y VGND VGND VPWR VPWR _2264_/A sky130_fd_sc_hd__buf_2
Xfanout31 _2116_/C VGND VGND VPWR VPWR _2726_/A sky130_fd_sc_hd__buf_2
Xfanout42 _2662_/A VGND VGND VPWR VPWR _1451_/B sky130_fd_sc_hd__clkbuf_2
XTAP_TAPCELL_ROW_24_277 VGND VPWR sky130_fd_sc_hd__tapvpwrvgnd_1
XFILLER_13_41 VGND VGND VPWR VPWR sky130_fd_sc_hd__decap_3
XFILLER_22_271 VGND VGND VPWR VPWR sky130_fd_sc_hd__decap_3
XFILLER_13_63 VGND VGND VPWR VPWR sky130_fd_sc_hd__fill_2
XFILLER_13_96 VGND VGND VPWR VPWR sky130_fd_sc_hd__decap_3
XFILLER_49_113 VGND VGND VPWR VPWR sky130_fd_sc_hd__fill_2
XFILLER_49_146 VGND VGND VPWR VPWR sky130_fd_sc_hd__decap_3
XFILLER_49_135 VGND VGND VPWR VPWR sky130_fd_sc_hd__fill_1
XFILLER_38_82 VGND VGND VPWR VPWR sky130_fd_sc_hd__fill_2
X_1990_ _2037_/A _1993_/B VGND VGND VPWR VPWR _1997_/A sky130_fd_sc_hd__and2b_1
XTAP_TAPCELL_ROW_15_222 VGND VPWR sky130_fd_sc_hd__tapvpwrvgnd_1
XFILLER_60_355 VGND VGND VPWR VPWR sky130_fd_sc_hd__decap_3
XFILLER_60_333 VGND VGND VPWR VPWR sky130_fd_sc_hd__decap_3
XFILLER_54_70 VGND VGND VPWR VPWR sky130_fd_sc_hd__decap_3
X_2611_ _2611_/A _2611_/B VGND VGND VPWR VPWR _2612_/A sky130_fd_sc_hd__nor2_1
X_2542_ _2583_/A _2583_/B VGND VGND VPWR VPWR _2542_/Y sky130_fd_sc_hd__nor2_1
XFILLER_55_3 VGND VGND VPWR VPWR sky130_fd_sc_hd__decap_3
X_2473_ _2473_/A _2475_/A VGND VGND VPWR VPWR _2535_/B sky130_fd_sc_hd__nand2_1
X_1424_ _1622_/A VGND VGND VPWR VPWR _1425_/B sky130_fd_sc_hd__inv_2
XFILLER_55_149 VGND VGND VPWR VPWR sky130_fd_sc_hd__decap_3
XFILLER_55_127 VGND VGND VPWR VPWR sky130_fd_sc_hd__fill_2
XTAP_TAPCELL_ROW_38_358 VGND VPWR sky130_fd_sc_hd__tapvpwrvgnd_1
XFILLER_48_190 VGND VGND VPWR VPWR sky130_fd_sc_hd__decap_3
XFILLER_51_311 VGND VGND VPWR VPWR sky130_fd_sc_hd__decap_3
XFILLER_34_18 VGND VGND VPWR VPWR sky130_fd_sc_hd__decap_3
XFILLER_51_355 VGND VGND VPWR VPWR sky130_fd_sc_hd__decap_3
XFILLER_11_208 VGND VGND VPWR VPWR sky130_fd_sc_hd__decap_3
XTAP_TAPCELL_ROW_21_258 VGND VPWR sky130_fd_sc_hd__tapvpwrvgnd_1
XFILLER_59_15 VGND VGND VPWR VPWR sky130_fd_sc_hd__decap_3
XFILLER_59_48 VGND VGND VPWR VPWR sky130_fd_sc_hd__decap_3
XFILLER_19_308 VGND VGND VPWR VPWR sky130_fd_sc_hd__decap_3
XTAP_TAPCELL_ROW_29_303 VGND VPWR sky130_fd_sc_hd__tapvpwrvgnd_1
XFILLER_46_127 VGND VGND VPWR VPWR sky130_fd_sc_hd__decap_3
XTAP_TAPCELL_ROW_12_203 VGND VPWR sky130_fd_sc_hd__tapvpwrvgnd_1
XFILLER_10_230 VGND VGND VPWR VPWR sky130_fd_sc_hd__fill_1
XFILLER_10_274 VGND VGND VPWR VPWR sky130_fd_sc_hd__fill_1
XFILLER_6_234 VGND VGND VPWR VPWR sky130_fd_sc_hd__decap_3
XFILLER_10_296 VGND VGND VPWR VPWR sky130_fd_sc_hd__decap_3
XFILLER_6_245 VGND VGND VPWR VPWR sky130_fd_sc_hd__decap_3
XFILLER_40_83 VGND VGND VPWR VPWR sky130_fd_sc_hd__fill_1
XFILLER_41_9 VGND VGND VPWR VPWR sky130_fd_sc_hd__decap_3
XFILLER_49_81 VGND VGND VPWR VPWR sky130_fd_sc_hd__decap_3
XFILLER_37_105 VGND VGND VPWR VPWR sky130_fd_sc_hd__decap_3
XFILLER_1_33 VGND VGND VPWR VPWR sky130_fd_sc_hd__decap_3
XFILLER_1_66 VGND VGND VPWR VPWR sky130_fd_sc_hd__decap_3
XFILLER_52_119 VGND VGND VPWR VPWR sky130_fd_sc_hd__decap_3
XFILLER_33_311 VGND VGND VPWR VPWR sky130_fd_sc_hd__decap_3
XTAP_TAPCELL_ROW_35_339 VGND VPWR sky130_fd_sc_hd__tapvpwrvgnd_1
XFILLER_60_141 VGND VGND VPWR VPWR sky130_fd_sc_hd__decap_3
X_1973_ _2217_/A _2034_/B _1971_/Y VGND VGND VPWR VPWR _1979_/A sky130_fd_sc_hd__o21a_1
X_2525_ _2525_/A _2525_/B VGND VGND VPWR VPWR _2541_/A sky130_fd_sc_hd__xnor2_2
X_2456_ _2456_/A _2456_/B VGND VGND VPWR VPWR _2457_/B sky130_fd_sc_hd__and2_1
X_1407_ _2021_/A _1663_/A VGND VGND VPWR VPWR _1408_/C sky130_fd_sc_hd__or2_1
X_2387_ _2387_/A _2387_/B VGND VGND VPWR VPWR _2478_/A sky130_fd_sc_hd__xnor2_2
XFILLER_28_116 VGND VGND VPWR VPWR sky130_fd_sc_hd__decap_3
XFILLER_43_108 VGND VGND VPWR VPWR sky130_fd_sc_hd__decap_3
XFILLER_24_300 VGND VGND VPWR VPWR sky130_fd_sc_hd__decap_3
XFILLER_24_344 VGND VGND VPWR VPWR sky130_fd_sc_hd__fill_1
XFILLER_24_333 VGND VGND VPWR VPWR sky130_fd_sc_hd__fill_1
XFILLER_24_322 VGND VGND VPWR VPWR sky130_fd_sc_hd__decap_3
XFILLER_3_237 VGND VGND VPWR VPWR sky130_fd_sc_hd__fill_2
XFILLER_59_252 VGND VGND VPWR VPWR sky130_fd_sc_hd__decap_3
XFILLER_59_296 VGND VGND VPWR VPWR sky130_fd_sc_hd__decap_3
XFILLER_19_116 VGND VGND VPWR VPWR sky130_fd_sc_hd__decap_3
XTAP_TAPCELL_ROW_57_475 VGND VPWR sky130_fd_sc_hd__tapvpwrvgnd_1
XFILLER_27_160 VGND VGND VPWR VPWR sky130_fd_sc_hd__fill_2
XFILLER_15_300 VGND VGND VPWR VPWR sky130_fd_sc_hd__decap_3
XFILLER_42_163 VGND VGND VPWR VPWR sky130_fd_sc_hd__decap_3
XFILLER_35_83 VGND VGND VPWR VPWR sky130_fd_sc_hd__decap_3
XFILLER_30_336 VGND VGND VPWR VPWR sky130_fd_sc_hd__decap_3
XFILLER_30_358 VGND VGND VPWR VPWR sky130_fd_sc_hd__decap_3
XFILLER_51_60 VGND VGND VPWR VPWR sky130_fd_sc_hd__decap_3
X_2310_ _2732_/A _2310_/B _2310_/C VGND VGND VPWR VPWR _2312_/B sky130_fd_sc_hd__and3_1
X_2241_ _2236_/X _2239_/Y _2240_/X _2188_/B VGND VGND VPWR VPWR _2244_/A sky130_fd_sc_hd__a211oi_1
XFILLER_2_292 VGND VGND VPWR VPWR sky130_fd_sc_hd__decap_3
X_2172_ _2307_/A _2172_/B VGND VGND VPWR VPWR _2227_/A sky130_fd_sc_hd__and2b_1
XFILLER_18_3 VGND VGND VPWR VPWR sky130_fd_sc_hd__decap_3
XTAP_TAPCELL_ROW_48_420 VGND VPWR sky130_fd_sc_hd__tapvpwrvgnd_1
XFILLER_25_119 VGND VGND VPWR VPWR sky130_fd_sc_hd__decap_3
XFILLER_21_303 VGND VGND VPWR VPWR sky130_fd_sc_hd__decap_3
XFILLER_33_196 VGND VGND VPWR VPWR sky130_fd_sc_hd__fill_1
X_1956_ _1957_/A _1957_/B VGND VGND VPWR VPWR _1967_/A sky130_fd_sc_hd__or2_1
X_1887_ _1878_/C _1947_/A _1886_/X VGND VGND VPWR VPWR _1960_/B sky130_fd_sc_hd__o21ai_1
X_2508_ _2643_/A _2527_/A VGND VGND VPWR VPWR _2595_/B sky130_fd_sc_hd__nor2_1
X_2439_ _2439_/A _2444_/A VGND VGND VPWR VPWR _2440_/B sky130_fd_sc_hd__or2_1
XFILLER_56_38 VGND VGND VPWR VPWR sky130_fd_sc_hd__decap_3
XFILLER_56_27 VGND VGND VPWR VPWR sky130_fd_sc_hd__fill_1
XFILLER_56_222 VGND VGND VPWR VPWR sky130_fd_sc_hd__decap_3
XFILLER_56_200 VGND VGND VPWR VPWR sky130_fd_sc_hd__decap_3
XFILLER_56_244 VGND VGND VPWR VPWR sky130_fd_sc_hd__decap_3
XFILLER_56_277 VGND VGND VPWR VPWR sky130_fd_sc_hd__decap_3
XTAP_TAPCELL_ROW_54_456 VGND VPWR sky130_fd_sc_hd__tapvpwrvgnd_1
XFILLER_12_336 VGND VGND VPWR VPWR sky130_fd_sc_hd__decap_3
XFILLER_24_163 VGND VGND VPWR VPWR sky130_fd_sc_hd__decap_3
XFILLER_8_318 VGND VGND VPWR VPWR sky130_fd_sc_hd__fill_2
XFILLER_21_52 VGND VGND VPWR VPWR sky130_fd_sc_hd__decap_3
XFILLER_21_96 VGND VGND VPWR VPWR sky130_fd_sc_hd__decap_3
XFILLER_47_200 VGND VGND VPWR VPWR sky130_fd_sc_hd__decap_3
XFILLER_47_244 VGND VGND VPWR VPWR sky130_fd_sc_hd__decap_3
XTAP_TAPCELL_ROW_45_401 VGND VPWR sky130_fd_sc_hd__tapvpwrvgnd_1
XFILLER_47_288 VGND VGND VPWR VPWR sky130_fd_sc_hd__decap_3
XFILLER_46_82 VGND VGND VPWR VPWR sky130_fd_sc_hd__fill_2
XFILLER_15_196 VGND VGND VPWR VPWR sky130_fd_sc_hd__fill_1
X_1810_ _1801_/A _1661_/Y _1809_/X VGND VGND VPWR VPWR _1889_/B sky130_fd_sc_hd__o21ai_1
XFILLER_7_21 VGND VGND VPWR VPWR sky130_fd_sc_hd__decap_3
XFILLER_30_166 VGND VGND VPWR VPWR sky130_fd_sc_hd__fill_1
X_1741_ _1742_/A _1742_/B VGND VGND VPWR VPWR _1741_/Y sky130_fd_sc_hd__nand2b_1
X_1672_ _1672_/A _1817_/B VGND VGND VPWR VPWR _1675_/B sky130_fd_sc_hd__nor2_1
XFILLER_7_87 VGND VGND VPWR VPWR sky130_fd_sc_hd__decap_3
X_2224_ _2328_/A _2224_/B VGND VGND VPWR VPWR _2267_/B sky130_fd_sc_hd__nor2_1
X_2155_ _1441_/A _1441_/B _1898_/A VGND VGND VPWR VPWR _2155_/Y sky130_fd_sc_hd__a21oi_1
XFILLER_38_222 VGND VGND VPWR VPWR sky130_fd_sc_hd__decap_3
XFILLER_53_203 VGND VGND VPWR VPWR sky130_fd_sc_hd__decap_3
X_2086_ _2742_/A _2335_/B _2146_/B _2084_/X VGND VGND VPWR VPWR _2088_/B sky130_fd_sc_hd__a31oi_2
XFILLER_53_247 VGND VGND VPWR VPWR sky130_fd_sc_hd__decap_3
XFILLER_53_258 VGND VGND VPWR VPWR sky130_fd_sc_hd__fill_1
XTAP_TAPCELL_ROW_51_437 VGND VPWR sky130_fd_sc_hd__tapvpwrvgnd_1
XFILLER_21_111 VGND VGND VPWR VPWR sky130_fd_sc_hd__fill_1
XFILLER_42_29 VGND VGND VPWR VPWR sky130_fd_sc_hd__fill_1
XFILLER_42_18 VGND VGND VPWR VPWR sky130_fd_sc_hd__decap_3
XFILLER_21_144 VGND VGND VPWR VPWR sky130_fd_sc_hd__fill_2
XFILLER_21_122 VGND VGND VPWR VPWR sky130_fd_sc_hd__decap_3
X_1939_ _2014_/A _2014_/B VGND VGND VPWR VPWR _1940_/B sky130_fd_sc_hd__and2b_1
XFILLER_21_199 VGND VGND VPWR VPWR sky130_fd_sc_hd__decap_3
XFILLER_29_200 VGND VGND VPWR VPWR sky130_fd_sc_hd__decap_3
XFILLER_29_222 VGND VGND VPWR VPWR sky130_fd_sc_hd__fill_2
XFILLER_29_255 VGND VGND VPWR VPWR sky130_fd_sc_hd__decap_3
XFILLER_44_236 VGND VGND VPWR VPWR sky130_fd_sc_hd__decap_3
XFILLER_29_299 VGND VGND VPWR VPWR sky130_fd_sc_hd__decap_3
XFILLER_12_100 VGND VGND VPWR VPWR sky130_fd_sc_hd__decap_3
XPHY_EDGE_ROW_11_Right_11 VGND VGND VPWR VPWR sky130_fd_sc_hd__decap_3
XFILLER_52_280 VGND VGND VPWR VPWR sky130_fd_sc_hd__decap_3
XFILLER_16_85 VGND VGND VPWR VPWR sky130_fd_sc_hd__decap_3
XFILLER_16_74 VGND VGND VPWR VPWR sky130_fd_sc_hd__fill_1
XFILLER_12_177 VGND VGND VPWR VPWR sky130_fd_sc_hd__decap_3
XFILLER_8_115 VGND VGND VPWR VPWR sky130_fd_sc_hd__decap_3
XFILLER_8_148 VGND VGND VPWR VPWR sky130_fd_sc_hd__fill_2
XFILLER_32_62 VGND VGND VPWR VPWR sky130_fd_sc_hd__decap_3
XFILLER_4_354 VGND VGND VPWR VPWR sky130_fd_sc_hd__decap_3
XPHY_EDGE_ROW_20_Right_20 VGND VGND VPWR VPWR sky130_fd_sc_hd__decap_3
XTAP_TAPCELL_ROW_7_170 VGND VPWR sky130_fd_sc_hd__tapvpwrvgnd_1
XFILLER_57_92 VGND VGND VPWR VPWR sky130_fd_sc_hd__decap_3
XFILLER_35_247 VGND VGND VPWR VPWR sky130_fd_sc_hd__decap_3
XFILLER_35_225 VGND VGND VPWR VPWR sky130_fd_sc_hd__decap_3
X_2773_ _2777_/CLK _2773_/D fanout48/X VGND VGND VPWR VPWR _2773_/Q sky130_fd_sc_hd__dfrtp_1
X_1724_ _1724_/A _1724_/B VGND VGND VPWR VPWR _1727_/C sky130_fd_sc_hd__nor2_1
X_1655_ _1655_/A _1655_/B VGND VGND VPWR VPWR _1666_/A sky130_fd_sc_hd__xnor2_1
X_1586_ _1586_/A _1586_/B VGND VGND VPWR VPWR _1587_/B sky130_fd_sc_hd__nand2_1
XFILLER_58_339 VGND VGND VPWR VPWR sky130_fd_sc_hd__decap_3
X_2207_ _2735_/A _2742_/A _2310_/B VGND VGND VPWR VPWR _2210_/A sky130_fd_sc_hd__and3_1
XFILLER_37_18 VGND VGND VPWR VPWR sky130_fd_sc_hd__decap_3
X_2138_ _2138_/A _2138_/B VGND VGND VPWR VPWR _2140_/B sky130_fd_sc_hd__xnor2_1
XFILLER_26_236 VGND VGND VPWR VPWR sky130_fd_sc_hd__decap_3
X_2069_ _2071_/A _2071_/B VGND VGND VPWR VPWR _2073_/A sky130_fd_sc_hd__nand2b_1
XFILLER_41_206 VGND VGND VPWR VPWR sky130_fd_sc_hd__decap_3
XFILLER_53_39 VGND VGND VPWR VPWR sky130_fd_sc_hd__decap_3
XFILLER_34_280 VGND VGND VPWR VPWR sky130_fd_sc_hd__decap_3
XFILLER_1_313 VGND VGND VPWR VPWR sky130_fd_sc_hd__fill_2
XFILLER_1_357 VGND VGND VPWR VPWR sky130_fd_sc_hd__fill_1
XFILLER_49_317 VGND VGND VPWR VPWR sky130_fd_sc_hd__decap_3
XFILLER_27_51 VGND VGND VPWR VPWR sky130_fd_sc_hd__decap_3
XFILLER_27_40 VGND VGND VPWR VPWR sky130_fd_sc_hd__decap_3
XFILLER_17_225 VGND VGND VPWR VPWR sky130_fd_sc_hd__decap_3
XFILLER_27_84 VGND VGND VPWR VPWR sky130_fd_sc_hd__decap_3
XFILLER_17_269 VGND VGND VPWR VPWR sky130_fd_sc_hd__fill_1
XFILLER_32_206 VGND VGND VPWR VPWR sky130_fd_sc_hd__decap_3
XFILLER_40_261 VGND VGND VPWR VPWR sky130_fd_sc_hd__decap_3
XFILLER_40_272 VGND VGND VPWR VPWR sky130_fd_sc_hd__decap_3
X_1440_ _1441_/A _1441_/B VGND VGND VPWR VPWR _2206_/B sky130_fd_sc_hd__and2_2
XFILLER_4_184 VGND VGND VPWR VPWR sky130_fd_sc_hd__decap_3
XFILLER_4_44 VGND VGND VPWR VPWR sky130_fd_sc_hd__fill_2
XFILLER_4_88 VGND VGND VPWR VPWR sky130_fd_sc_hd__decap_3
XFILLER_31_272 VGND VGND VPWR VPWR sky130_fd_sc_hd__decap_3
X_2756_ _2757_/B _2756_/B VGND VGND VPWR VPWR _2774_/D sky130_fd_sc_hd__and2b_1
X_1707_ _2045_/B _2264_/A _1844_/A VGND VGND VPWR VPWR _1849_/A sky130_fd_sc_hd__o21ba_1
X_2687_ _2687_/A _2687_/B VGND VGND VPWR VPWR _2687_/Y sky130_fd_sc_hd__xnor2_1
X_1638_ _1638_/A _1638_/B VGND VGND VPWR VPWR _1640_/C sky130_fd_sc_hd__nor2_1
X_1569_ _1569_/A _1569_/B VGND VGND VPWR VPWR _1579_/A sky130_fd_sc_hd__nor2_1
XFILLER_58_147 VGND VGND VPWR VPWR sky130_fd_sc_hd__decap_3
XFILLER_54_342 VGND VGND VPWR VPWR sky130_fd_sc_hd__decap_3
XFILLER_14_206 VGND VGND VPWR VPWR sky130_fd_sc_hd__decap_3
Xfanout21 _1456_/Y VGND VGND VPWR VPWR _2045_/B sky130_fd_sc_hd__buf_2
Xfanout32 _2773_/Q VGND VGND VPWR VPWR _2754_/A sky130_fd_sc_hd__buf_4
Xfanout43 _2662_/A VGND VGND VPWR VPWR _2669_/A sky130_fd_sc_hd__buf_2
XFILLER_22_250 VGND VGND VPWR VPWR sky130_fd_sc_hd__fill_2
XFILLER_22_283 VGND VGND VPWR VPWR sky130_fd_sc_hd__decap_3
XFILLER_13_75 VGND VGND VPWR VPWR sky130_fd_sc_hd__decap_3
XFILLER_1_110 VGND VGND VPWR VPWR sky130_fd_sc_hd__fill_2
XFILLER_49_103 VGND VGND VPWR VPWR sky130_fd_sc_hd__decap_3
XFILLER_49_169 VGND VGND VPWR VPWR sky130_fd_sc_hd__decap_3
XFILLER_38_94 VGND VGND VPWR VPWR sky130_fd_sc_hd__decap_3
XFILLER_57_191 VGND VGND VPWR VPWR sky130_fd_sc_hd__decap_3
XFILLER_45_342 VGND VGND VPWR VPWR sky130_fd_sc_hd__decap_3
XFILLER_60_312 VGND VGND VPWR VPWR sky130_fd_sc_hd__decap_3
XTAP_TAPCELL_ROW_15_223 VGND VPWR sky130_fd_sc_hd__tapvpwrvgnd_1
XFILLER_54_82 VGND VGND VPWR VPWR sky130_fd_sc_hd__fill_2
XFILLER_13_261 VGND VGND VPWR VPWR sky130_fd_sc_hd__decap_3
XFILLER_9_210 VGND VGND VPWR VPWR sky130_fd_sc_hd__decap_3
XFILLER_9_276 VGND VGND VPWR VPWR sky130_fd_sc_hd__decap_3
X_2610_ _2610_/A _2610_/B VGND VGND VPWR VPWR _2611_/B sky130_fd_sc_hd__and2_1
XFILLER_9_287 VGND VGND VPWR VPWR sky130_fd_sc_hd__decap_3
X_2541_ _2541_/A _2552_/A VGND VGND VPWR VPWR _2583_/B sky130_fd_sc_hd__xnor2_1
X_2472_ _2473_/A _2475_/A VGND VGND VPWR VPWR _2472_/Y sky130_fd_sc_hd__nor2_1
X_1423_ _1587_/A _1582_/A VGND VGND VPWR VPWR _1622_/A sky130_fd_sc_hd__nor2_1
XFILLER_55_139 VGND VGND VPWR VPWR sky130_fd_sc_hd__decap_3
XTAP_TAPCELL_ROW_38_359 VGND VPWR sky130_fd_sc_hd__tapvpwrvgnd_1
XFILLER_36_353 VGND VGND VPWR VPWR sky130_fd_sc_hd__decap_3
XFILLER_36_331 VGND VGND VPWR VPWR sky130_fd_sc_hd__decap_3
XFILLER_51_323 VGND VGND VPWR VPWR sky130_fd_sc_hd__decap_3
XTAP_TAPCELL_ROW_21_259 VGND VPWR sky130_fd_sc_hd__tapvpwrvgnd_1
XFILLER_50_29 VGND VGND VPWR VPWR sky130_fd_sc_hd__fill_2
XFILLER_50_18 VGND VGND VPWR VPWR sky130_fd_sc_hd__decap_3
X_2739_ _2764_/Q _2765_/Q _2739_/C VGND VGND VPWR VPWR _2742_/B sky130_fd_sc_hd__and3_1
XFILLER_59_27 VGND VGND VPWR VPWR sky130_fd_sc_hd__decap_3
XFILLER_1_9 VGND VGND VPWR VPWR sky130_fd_sc_hd__decap_3
XFILLER_46_106 VGND VGND VPWR VPWR sky130_fd_sc_hd__decap_3
XTAP_TAPCELL_ROW_29_304 VGND VPWR sky130_fd_sc_hd__tapvpwrvgnd_1
XFILLER_46_139 VGND VGND VPWR VPWR sky130_fd_sc_hd__fill_1
XFILLER_27_353 VGND VGND VPWR VPWR sky130_fd_sc_hd__decap_3
XFILLER_27_331 VGND VGND VPWR VPWR sky130_fd_sc_hd__decap_3
XFILLER_42_312 VGND VGND VPWR VPWR sky130_fd_sc_hd__decap_3
XFILLER_54_194 VGND VGND VPWR VPWR sky130_fd_sc_hd__fill_2
XFILLER_42_334 VGND VGND VPWR VPWR sky130_fd_sc_hd__decap_3
XTAP_TAPCELL_ROW_12_204 VGND VPWR sky130_fd_sc_hd__tapvpwrvgnd_1
XFILLER_24_85 VGND VGND VPWR VPWR sky130_fd_sc_hd__decap_3
XFILLER_24_63 VGND VGND VPWR VPWR sky130_fd_sc_hd__decap_3
XFILLER_10_253 VGND VGND VPWR VPWR sky130_fd_sc_hd__decap_3
XFILLER_40_40 VGND VGND VPWR VPWR sky130_fd_sc_hd__decap_3
XFILLER_34_9 VGND VGND VPWR VPWR sky130_fd_sc_hd__decap_3
XFILLER_1_12 VGND VGND VPWR VPWR sky130_fd_sc_hd__decap_3
XFILLER_37_128 VGND VGND VPWR VPWR sky130_fd_sc_hd__decap_3
XFILLER_1_45 VGND VGND VPWR VPWR sky130_fd_sc_hd__decap_3
XFILLER_1_78 VGND VGND VPWR VPWR sky130_fd_sc_hd__decap_3
XFILLER_18_353 VGND VGND VPWR VPWR sky130_fd_sc_hd__decap_3
XFILLER_45_172 VGND VGND VPWR VPWR sky130_fd_sc_hd__decap_3
XFILLER_60_131 VGND VGND VPWR VPWR sky130_fd_sc_hd__decap_3
XFILLER_45_194 VGND VGND VPWR VPWR sky130_fd_sc_hd__decap_3
XFILLER_33_323 VGND VGND VPWR VPWR sky130_fd_sc_hd__decap_3
XFILLER_60_153 VGND VGND VPWR VPWR sky130_fd_sc_hd__decap_3
X_1972_ _1972_/A _1972_/B VGND VGND VPWR VPWR _2034_/B sky130_fd_sc_hd__or2_1
XFILLER_60_197 VGND VGND VPWR VPWR sky130_fd_sc_hd__decap_3
XFILLER_60_175 VGND VGND VPWR VPWR sky130_fd_sc_hd__decap_3
XPHY_EDGE_ROW_49_Right_49 VGND VGND VPWR VPWR sky130_fd_sc_hd__decap_3
X_2524_ _2591_/A _2591_/B VGND VGND VPWR VPWR _2524_/X sky130_fd_sc_hd__or2_2
XFILLER_5_290 VGND VGND VPWR VPWR sky130_fd_sc_hd__fill_1
X_2455_ _2455_/A _2455_/B _2455_/C VGND VGND VPWR VPWR _2456_/B sky130_fd_sc_hd__or3_1
X_1406_ _1960_/A _1663_/A VGND VGND VPWR VPWR _1408_/B sky130_fd_sc_hd__nand2b_1
X_2386_ _2194_/X _2386_/B VGND VGND VPWR VPWR _2387_/B sky130_fd_sc_hd__and2b_1
XFILLER_28_139 VGND VGND VPWR VPWR sky130_fd_sc_hd__fill_1
XPHY_EDGE_ROW_58_Right_58 VGND VGND VPWR VPWR sky130_fd_sc_hd__decap_3
XFILLER_45_18 VGND VGND VPWR VPWR sky130_fd_sc_hd__decap_3
XFILLER_36_194 VGND VGND VPWR VPWR sky130_fd_sc_hd__fill_2
XFILLER_51_142 VGND VGND VPWR VPWR sky130_fd_sc_hd__decap_3
XFILLER_51_131 VGND VGND VPWR VPWR sky130_fd_sc_hd__fill_1
XFILLER_10_10 VGND VGND VPWR VPWR sky130_fd_sc_hd__decap_3
XFILLER_10_32 VGND VGND VPWR VPWR sky130_fd_sc_hd__decap_3
XFILLER_10_76 VGND VGND VPWR VPWR sky130_fd_sc_hd__decap_3
XFILLER_10_98 VGND VGND VPWR VPWR sky130_fd_sc_hd__decap_3
XFILLER_59_231 VGND VGND VPWR VPWR sky130_fd_sc_hd__decap_3
XFILLER_59_264 VGND VGND VPWR VPWR sky130_fd_sc_hd__decap_3
XFILLER_42_120 VGND VGND VPWR VPWR sky130_fd_sc_hd__decap_3
XFILLER_35_40 VGND VGND VPWR VPWR sky130_fd_sc_hd__decap_3
XFILLER_27_172 VGND VGND VPWR VPWR sky130_fd_sc_hd__decap_3
XFILLER_15_312 VGND VGND VPWR VPWR sky130_fd_sc_hd__decap_3
XFILLER_30_315 VGND VGND VPWR VPWR sky130_fd_sc_hd__decap_3
XFILLER_51_72 VGND VGND VPWR VPWR sky130_fd_sc_hd__decap_3
X_2240_ _2188_/A _2186_/X _2178_/Y _2180_/Y VGND VGND VPWR VPWR _2240_/X sky130_fd_sc_hd__o211a_1
XFILLER_32_6 VGND VGND VPWR VPWR sky130_fd_sc_hd__decap_3
X_2171_ _2171_/A _2171_/B VGND VGND VPWR VPWR _2172_/B sky130_fd_sc_hd__nand2_1
XTAP_TAPCELL_ROW_48_421 VGND VPWR sky130_fd_sc_hd__tapvpwrvgnd_1
XFILLER_25_109 VGND VGND VPWR VPWR sky130_fd_sc_hd__decap_3
XFILLER_33_175 VGND VGND VPWR VPWR sky130_fd_sc_hd__decap_3
X_1955_ _1955_/A _1955_/B VGND VGND VPWR VPWR _1957_/B sky130_fd_sc_hd__or2_1
XFILLER_21_359 VGND VGND VPWR VPWR sky130_fd_sc_hd__fill_2
X_1886_ _1886_/A _1886_/B _2283_/A VGND VGND VPWR VPWR _1886_/X sky130_fd_sc_hd__or3_1
X_2507_ _2507_/A _2507_/B VGND VGND VPWR VPWR _2527_/A sky130_fd_sc_hd__xnor2_2
X_2438_ _2694_/A _2438_/B VGND VGND VPWR VPWR _2687_/A sky130_fd_sc_hd__nand2_1
X_2369_ _2194_/X _2244_/X _2392_/A _2386_/B _2143_/Y VGND VGND VPWR VPWR _2383_/A
+ sky130_fd_sc_hd__o311a_1
XFILLER_56_256 VGND VGND VPWR VPWR sky130_fd_sc_hd__decap_3
XFILLER_56_289 VGND VGND VPWR VPWR sky130_fd_sc_hd__decap_3
XTAP_TAPCELL_ROW_54_457 VGND VPWR sky130_fd_sc_hd__tapvpwrvgnd_1
XFILLER_24_175 VGND VGND VPWR VPWR sky130_fd_sc_hd__decap_3
XFILLER_12_359 VGND VGND VPWR VPWR sky130_fd_sc_hd__fill_2
XFILLER_24_197 VGND VGND VPWR VPWR sky130_fd_sc_hd__decap_3
XFILLER_21_75 VGND VGND VPWR VPWR sky130_fd_sc_hd__decap_3
XFILLER_47_223 VGND VGND VPWR VPWR sky130_fd_sc_hd__fill_1
XTAP_TAPCELL_ROW_45_402 VGND VPWR sky130_fd_sc_hd__tapvpwrvgnd_1
XFILLER_47_267 VGND VGND VPWR VPWR sky130_fd_sc_hd__fill_2
XFILLER_46_50 VGND VGND VPWR VPWR sky130_fd_sc_hd__decap_3
XFILLER_46_94 VGND VGND VPWR VPWR sky130_fd_sc_hd__decap_3
XFILLER_30_101 VGND VGND VPWR VPWR sky130_fd_sc_hd__fill_1
XFILLER_30_123 VGND VGND VPWR VPWR sky130_fd_sc_hd__decap_3
X_1740_ _1534_/A _1972_/A _1558_/B VGND VGND VPWR VPWR _1742_/B sky130_fd_sc_hd__a21o_1
XFILLER_7_55 VGND VGND VPWR VPWR sky130_fd_sc_hd__fill_1
XFILLER_7_330 VGND VGND VPWR VPWR sky130_fd_sc_hd__decap_3
XFILLER_7_33 VGND VGND VPWR VPWR sky130_fd_sc_hd__decap_3
XFILLER_30_189 VGND VGND VPWR VPWR sky130_fd_sc_hd__decap_3
X_1671_ _1671_/A _1671_/B VGND VGND VPWR VPWR _1817_/B sky130_fd_sc_hd__xor2_1
XFILLER_7_352 VGND VGND VPWR VPWR sky130_fd_sc_hd__decap_3
XFILLER_7_99 VGND VGND VPWR VPWR sky130_fd_sc_hd__decap_3
XFILLER_30_3 VGND VGND VPWR VPWR sky130_fd_sc_hd__decap_3
X_2223_ _2356_/B _2222_/C _2208_/B VGND VGND VPWR VPWR _2224_/B sky130_fd_sc_hd__a21oi_1
X_2154_ _2203_/A _2164_/B VGND VGND VPWR VPWR _2154_/X sky130_fd_sc_hd__or2_1
XFILLER_38_234 VGND VGND VPWR VPWR sky130_fd_sc_hd__decap_3
XFILLER_38_256 VGND VGND VPWR VPWR sky130_fd_sc_hd__decap_3
X_2085_ _2149_/B _2208_/A VGND VGND VPWR VPWR _2146_/B sky130_fd_sc_hd__xnor2_1
XTAP_TAPCELL_ROW_51_438 VGND VPWR sky130_fd_sc_hd__tapvpwrvgnd_1
X_1938_ _1938_/A _1938_/B VGND VGND VPWR VPWR _2014_/B sky130_fd_sc_hd__xnor2_1
X_1869_ _1943_/A _1943_/B _1943_/C VGND VGND VPWR VPWR _1944_/A sky130_fd_sc_hd__o21a_1
XPHY_EDGE_ROW_48_Left_109 VGND VGND VPWR VPWR sky130_fd_sc_hd__decap_3
XFILLER_29_234 VGND VGND VPWR VPWR sky130_fd_sc_hd__decap_3
XFILLER_44_248 VGND VGND VPWR VPWR sky130_fd_sc_hd__decap_3
XFILLER_16_53 VGND VGND VPWR VPWR sky130_fd_sc_hd__decap_3
XFILLER_12_145 VGND VGND VPWR VPWR sky130_fd_sc_hd__decap_3
XFILLER_52_292 VGND VGND VPWR VPWR sky130_fd_sc_hd__decap_3
XFILLER_16_97 VGND VGND VPWR VPWR sky130_fd_sc_hd__decap_3
XPHY_EDGE_ROW_57_Left_118 VGND VGND VPWR VPWR sky130_fd_sc_hd__decap_3
XFILLER_8_127 VGND VGND VPWR VPWR sky130_fd_sc_hd__decap_3
XFILLER_12_189 VGND VGND VPWR VPWR sky130_fd_sc_hd__decap_3
XFILLER_32_41 VGND VGND VPWR VPWR sky130_fd_sc_hd__fill_2
XFILLER_32_96 VGND VGND VPWR VPWR sky130_fd_sc_hd__decap_3
XFILLER_32_85 VGND VGND VPWR VPWR sky130_fd_sc_hd__decap_3
XFILLER_4_322 VGND VGND VPWR VPWR sky130_fd_sc_hd__decap_3
XTAP_TAPCELL_ROW_7_171 VGND VPWR sky130_fd_sc_hd__tapvpwrvgnd_1
XFILLER_57_71 VGND VGND VPWR VPWR sky130_fd_sc_hd__decap_3
XFILLER_57_60 VGND VGND VPWR VPWR sky130_fd_sc_hd__decap_3
XFILLER_35_204 VGND VGND VPWR VPWR sky130_fd_sc_hd__decap_3
XFILLER_35_259 VGND VGND VPWR VPWR sky130_fd_sc_hd__decap_3
XFILLER_50_207 VGND VGND VPWR VPWR sky130_fd_sc_hd__decap_3
XFILLER_43_281 VGND VGND VPWR VPWR sky130_fd_sc_hd__decap_3
X_2772_ _2777_/CLK _2772_/D fanout48/X VGND VGND VPWR VPWR _2772_/Q sky130_fd_sc_hd__dfrtp_1
X_1723_ _1723_/A _1723_/B VGND VGND VPWR VPWR _1724_/B sky130_fd_sc_hd__and2_1
X_1654_ _1654_/A _1654_/B VGND VGND VPWR VPWR _1870_/A sky130_fd_sc_hd__nand2_1
X_1585_ _1809_/A _1582_/A _2199_/B _1603_/A VGND VGND VPWR VPWR _1588_/A sky130_fd_sc_hd__o31a_1
XFILLER_58_318 VGND VGND VPWR VPWR sky130_fd_sc_hd__decap_3
XFILLER_58_307 VGND VGND VPWR VPWR sky130_fd_sc_hd__fill_1
X_2206_ _2206_/A _2206_/B _2253_/A VGND VGND VPWR VPWR _2211_/A sky130_fd_sc_hd__or3_1
X_2137_ _2189_/A _2136_/B _2133_/X VGND VGND VPWR VPWR _2140_/A sky130_fd_sc_hd__a21o_1
X_2068_ _2068_/A _2068_/B VGND VGND VPWR VPWR _2071_/B sky130_fd_sc_hd__xnor2_1
XFILLER_53_18 VGND VGND VPWR VPWR sky130_fd_sc_hd__decap_3
XFILLER_26_259 VGND VGND VPWR VPWR sky130_fd_sc_hd__decap_3
XFILLER_5_108 VGND VGND VPWR VPWR sky130_fd_sc_hd__decap_3
XFILLER_1_325 VGND VGND VPWR VPWR sky130_fd_sc_hd__decap_3
XFILLER_49_329 VGND VGND VPWR VPWR sky130_fd_sc_hd__decap_3
XTAP_TAPCELL_ROW_4_152 VGND VPWR sky130_fd_sc_hd__tapvpwrvgnd_1
XFILLER_57_340 VGND VGND VPWR VPWR sky130_fd_sc_hd__decap_3
XFILLER_27_63 VGND VGND VPWR VPWR sky130_fd_sc_hd__decap_3
XFILLER_17_237 VGND VGND VPWR VPWR sky130_fd_sc_hd__decap_3
XFILLER_17_204 VGND VGND VPWR VPWR sky130_fd_sc_hd__decap_3
XFILLER_27_96 VGND VGND VPWR VPWR sky130_fd_sc_hd__decap_3
XFILLER_43_40 VGND VGND VPWR VPWR sky130_fd_sc_hd__decap_3
XFILLER_25_281 VGND VGND VPWR VPWR sky130_fd_sc_hd__decap_3
XFILLER_40_284 VGND VGND VPWR VPWR sky130_fd_sc_hd__fill_2
XFILLER_4_141 VGND VGND VPWR VPWR sky130_fd_sc_hd__decap_3
XFILLER_4_130 VGND VGND VPWR VPWR sky130_fd_sc_hd__decap_3
XFILLER_4_12 VGND VGND VPWR VPWR sky130_fd_sc_hd__decap_3
XFILLER_4_78 VGND VGND VPWR VPWR sky130_fd_sc_hd__decap_3
XFILLER_48_351 VGND VGND VPWR VPWR sky130_fd_sc_hd__decap_3
XFILLER_31_251 VGND VGND VPWR VPWR sky130_fd_sc_hd__decap_3
XFILLER_31_240 VGND VGND VPWR VPWR sky130_fd_sc_hd__decap_3
XFILLER_31_295 VGND VGND VPWR VPWR sky130_fd_sc_hd__fill_2
X_2755_ _2754_/A _2772_/Q _2752_/B _2774_/Q VGND VGND VPWR VPWR _2756_/B sky130_fd_sc_hd__a31o_1
X_1706_ _1995_/A _1843_/B VGND VGND VPWR VPWR _1844_/A sky130_fd_sc_hd__and2_1
X_2686_ _2619_/X _2620_/Y _2685_/Y VGND VGND VPWR VPWR _2686_/X sky130_fd_sc_hd__o21a_1
X_1637_ _1637_/A _1637_/B VGND VGND VPWR VPWR _1638_/B sky130_fd_sc_hd__and2_1
X_1568_ _1671_/A _1568_/B VGND VGND VPWR VPWR _1569_/B sky130_fd_sc_hd__nor2_1
XFILLER_48_29 VGND VGND VPWR VPWR sky130_fd_sc_hd__decap_3
XFILLER_48_18 VGND VGND VPWR VPWR sky130_fd_sc_hd__decap_3
X_1499_ _1995_/A _1499_/B VGND VGND VPWR VPWR _1511_/B sky130_fd_sc_hd__xor2_1
XFILLER_39_340 VGND VGND VPWR VPWR sky130_fd_sc_hd__decap_3
XFILLER_54_321 VGND VGND VPWR VPWR sky130_fd_sc_hd__decap_3
XFILLER_54_354 VGND VGND VPWR VPWR sky130_fd_sc_hd__decap_3
XFILLER_14_229 VGND VGND VPWR VPWR sky130_fd_sc_hd__fill_1
XFILLER_14_218 VGND VGND VPWR VPWR sky130_fd_sc_hd__decap_3
Xfanout22 _1829_/A VGND VGND VPWR VPWR _2222_/A sky130_fd_sc_hd__buf_2
Xfanout33 _2771_/Q VGND VGND VPWR VPWR _2217_/A sky130_fd_sc_hd__buf_2
Xfanout44 _1387_/Y VGND VGND VPWR VPWR _2662_/A sky130_fd_sc_hd__buf_2
XFILLER_13_21 VGND VGND VPWR VPWR sky130_fd_sc_hd__decap_3
XFILLER_13_32 VGND VGND VPWR VPWR sky130_fd_sc_hd__decap_3
XFILLER_22_295 VGND VGND VPWR VPWR sky130_fd_sc_hd__decap_3
XFILLER_22_262 VGND VGND VPWR VPWR sky130_fd_sc_hd__decap_3
XFILLER_13_54 VGND VGND VPWR VPWR sky130_fd_sc_hd__fill_2
XFILLER_13_87 VGND VGND VPWR VPWR sky130_fd_sc_hd__decap_3
XFILLER_8_3 VGND VGND VPWR VPWR sky130_fd_sc_hd__decap_3
XFILLER_49_126 VGND VGND VPWR VPWR sky130_fd_sc_hd__decap_3
XFILLER_1_188 VGND VGND VPWR VPWR sky130_fd_sc_hd__decap_3
XFILLER_45_354 VGND VGND VPWR VPWR sky130_fd_sc_hd__decap_3
XFILLER_60_302 VGND VGND VPWR VPWR sky130_fd_sc_hd__decap_3
XFILLER_54_50 VGND VGND VPWR VPWR sky130_fd_sc_hd__decap_3
XFILLER_60_346 VGND VGND VPWR VPWR sky130_fd_sc_hd__decap_3
XFILLER_60_324 VGND VGND VPWR VPWR sky130_fd_sc_hd__decap_3
XFILLER_13_240 VGND VGND VPWR VPWR sky130_fd_sc_hd__decap_3
XFILLER_54_94 VGND VGND VPWR VPWR sky130_fd_sc_hd__decap_3
XFILLER_13_273 VGND VGND VPWR VPWR sky130_fd_sc_hd__fill_2
XFILLER_9_233 VGND VGND VPWR VPWR sky130_fd_sc_hd__fill_2
XFILLER_9_222 VGND VGND VPWR VPWR sky130_fd_sc_hd__fill_2
X_2540_ _2543_/A _2554_/A VGND VGND VPWR VPWR _2583_/A sky130_fd_sc_hd__or2_1
X_2471_ _2496_/A _2471_/B VGND VGND VPWR VPWR _2530_/A sky130_fd_sc_hd__nor2_1
X_1422_ _1886_/B _1582_/A VGND VGND VPWR VPWR _1669_/B sky130_fd_sc_hd__nor2_1
XFILLER_48_181 VGND VGND VPWR VPWR sky130_fd_sc_hd__decap_3
XFILLER_36_343 VGND VGND VPWR VPWR sky130_fd_sc_hd__decap_3
XFILLER_51_302 VGND VGND VPWR VPWR sky130_fd_sc_hd__decap_3
XFILLER_51_346 VGND VGND VPWR VPWR sky130_fd_sc_hd__decap_3
XFILLER_51_335 VGND VGND VPWR VPWR sky130_fd_sc_hd__fill_1
X_2738_ _2764_/Q _2739_/C _2765_/Q VGND VGND VPWR VPWR _2740_/A sky130_fd_sc_hd__a21oi_1
X_2669_ _2669_/A _2669_/B VGND VGND VPWR VPWR _2669_/Y sky130_fd_sc_hd__nand2_1
XFILLER_59_39 VGND VGND VPWR VPWR sky130_fd_sc_hd__decap_3
XTAP_TAPCELL_ROW_29_305 VGND VPWR sky130_fd_sc_hd__tapvpwrvgnd_1
XFILLER_27_321 VGND VGND VPWR VPWR sky130_fd_sc_hd__fill_2
XFILLER_54_184 VGND VGND VPWR VPWR sky130_fd_sc_hd__decap_3
XTAP_TAPCELL_ROW_12_205 VGND VPWR sky130_fd_sc_hd__tapvpwrvgnd_1
XFILLER_24_75 VGND VGND VPWR VPWR sky130_fd_sc_hd__decap_3
XFILLER_10_243 VGND VGND VPWR VPWR sky130_fd_sc_hd__fill_2
XFILLER_24_97 VGND VGND VPWR VPWR sky130_fd_sc_hd__fill_2
XFILLER_6_203 VGND VGND VPWR VPWR sky130_fd_sc_hd__decap_3
XFILLER_40_85 VGND VGND VPWR VPWR sky130_fd_sc_hd__decap_3
XFILLER_40_74 VGND VGND VPWR VPWR sky130_fd_sc_hd__decap_3
XFILLER_49_94 VGND VGND VPWR VPWR sky130_fd_sc_hd__decap_3
XFILLER_1_24 VGND VGND VPWR VPWR sky130_fd_sc_hd__decap_3
XFILLER_1_57 VGND VGND VPWR VPWR sky130_fd_sc_hd__decap_3
XFILLER_45_151 VGND VGND VPWR VPWR sky130_fd_sc_hd__decap_3
XFILLER_33_302 VGND VGND VPWR VPWR sky130_fd_sc_hd__decap_3
XFILLER_33_335 VGND VGND VPWR VPWR sky130_fd_sc_hd__fill_1
XFILLER_60_165 VGND VGND VPWR VPWR sky130_fd_sc_hd__decap_3
XFILLER_33_357 VGND VGND VPWR VPWR sky130_fd_sc_hd__decap_3
X_1971_ _2037_/A _2037_/B VGND VGND VPWR VPWR _1971_/Y sky130_fd_sc_hd__nand2b_1
XFILLER_60_187 VGND VGND VPWR VPWR sky130_fd_sc_hd__decap_3
XFILLER_60_3 VGND VGND VPWR VPWR sky130_fd_sc_hd__decap_3
X_2523_ _2527_/A _2537_/A VGND VGND VPWR VPWR _2591_/B sky130_fd_sc_hd__nor2_1
X_2454_ _2454_/A _2454_/B VGND VGND VPWR VPWR _2712_/A sky130_fd_sc_hd__or2_1
X_1405_ _1405_/A _1809_/A VGND VGND VPWR VPWR _1960_/A sky130_fd_sc_hd__or2_2
X_2385_ _2613_/A _2475_/A VGND VGND VPWR VPWR _2455_/A sky130_fd_sc_hd__xnor2_1
Xinput1 ena VGND VGND VPWR VPWR input1/X sky130_fd_sc_hd__clkbuf_1
XFILLER_51_165 VGND VGND VPWR VPWR sky130_fd_sc_hd__decap_3
XFILLER_3_217 VGND VGND VPWR VPWR sky130_fd_sc_hd__decap_3
XFILLER_10_22 VGND VGND VPWR VPWR sky130_fd_sc_hd__decap_3
XFILLER_3_228 VGND VGND VPWR VPWR sky130_fd_sc_hd__decap_3
XFILLER_59_243 VGND VGND VPWR VPWR sky130_fd_sc_hd__decap_3
XFILLER_59_287 VGND VGND VPWR VPWR sky130_fd_sc_hd__decap_3
XFILLER_59_276 VGND VGND VPWR VPWR sky130_fd_sc_hd__decap_3
XFILLER_27_151 VGND VGND VPWR VPWR sky130_fd_sc_hd__decap_3
XFILLER_35_52 VGND VGND VPWR VPWR sky130_fd_sc_hd__decap_3
XFILLER_27_184 VGND VGND VPWR VPWR sky130_fd_sc_hd__decap_3
XFILLER_15_335 VGND VGND VPWR VPWR sky130_fd_sc_hd__fill_1
XFILLER_15_324 VGND VGND VPWR VPWR sky130_fd_sc_hd__decap_3
XFILLER_42_187 VGND VGND VPWR VPWR sky130_fd_sc_hd__decap_3
XFILLER_42_176 VGND VGND VPWR VPWR sky130_fd_sc_hd__decap_3
XFILLER_30_327 VGND VGND VPWR VPWR sky130_fd_sc_hd__decap_3
XFILLER_30_349 VGND VGND VPWR VPWR sky130_fd_sc_hd__decap_3
XFILLER_51_95 VGND VGND VPWR VPWR sky130_fd_sc_hd__fill_2
XPHY_EDGE_ROW_27_Left_88 VGND VGND VPWR VPWR sky130_fd_sc_hd__decap_3
XFILLER_2_283 VGND VGND VPWR VPWR sky130_fd_sc_hd__decap_3
XFILLER_2_272 VGND VGND VPWR VPWR sky130_fd_sc_hd__decap_3
XFILLER_25_6 VGND VGND VPWR VPWR sky130_fd_sc_hd__decap_3
X_2170_ _2171_/A _2171_/B VGND VGND VPWR VPWR _2307_/A sky130_fd_sc_hd__nor2_1
XFILLER_33_110 VGND VGND VPWR VPWR sky130_fd_sc_hd__fill_2
XFILLER_18_195 VGND VGND VPWR VPWR sky130_fd_sc_hd__fill_1
XFILLER_18_184 VGND VGND VPWR VPWR sky130_fd_sc_hd__fill_1
X_1954_ _1881_/A _1881_/C _1947_/A VGND VGND VPWR VPWR _1955_/B sky130_fd_sc_hd__a21oi_1
X_1885_ _1885_/A _1885_/B VGND VGND VPWR VPWR _1965_/A sky130_fd_sc_hd__xnor2_1
X_2506_ _2506_/A _2506_/B VGND VGND VPWR VPWR _2507_/B sky130_fd_sc_hd__nor2_1
X_2437_ _2437_/A _2437_/B VGND VGND VPWR VPWR _2438_/B sky130_fd_sc_hd__nand2_1
X_2368_ _2367_/A _2367_/B _2367_/C _2244_/X VGND VGND VPWR VPWR _2387_/A sky130_fd_sc_hd__a31o_1
XFILLER_56_29 VGND VGND VPWR VPWR sky130_fd_sc_hd__decap_3
XFILLER_56_18 VGND VGND VPWR VPWR sky130_fd_sc_hd__decap_3
X_2299_ _2272_/A _2271_/B _2271_/C VGND VGND VPWR VPWR _2299_/X sky130_fd_sc_hd__o21a_1
XFILLER_56_268 VGND VGND VPWR VPWR sky130_fd_sc_hd__decap_3
XFILLER_12_305 VGND VGND VPWR VPWR sky130_fd_sc_hd__decap_3
XFILLER_12_327 VGND VGND VPWR VPWR sky130_fd_sc_hd__decap_3
XFILLER_24_187 VGND VGND VPWR VPWR sky130_fd_sc_hd__decap_3
XFILLER_8_309 VGND VGND VPWR VPWR sky130_fd_sc_hd__decap_3
XFILLER_21_87 VGND VGND VPWR VPWR sky130_fd_sc_hd__decap_3
XTAP_TAPCELL_ROW_45_403 VGND VPWR sky130_fd_sc_hd__tapvpwrvgnd_1
XFILLER_46_62 VGND VGND VPWR VPWR sky130_fd_sc_hd__decap_3
XFILLER_55_290 VGND VGND VPWR VPWR sky130_fd_sc_hd__decap_3
XFILLER_30_113 VGND VGND VPWR VPWR sky130_fd_sc_hd__fill_1
XFILLER_7_12 VGND VGND VPWR VPWR sky130_fd_sc_hd__decap_3
XFILLER_11_360 VGND VGND VPWR VPWR sky130_fd_sc_hd__fill_1
XFILLER_7_45 VGND VGND VPWR VPWR sky130_fd_sc_hd__decap_3
X_1670_ _1670_/A _1670_/B VGND VGND VPWR VPWR _1671_/B sky130_fd_sc_hd__nand2_1
XFILLER_7_78 VGND VGND VPWR VPWR sky130_fd_sc_hd__decap_3
X_2222_ _2222_/A _2356_/B _2222_/C VGND VGND VPWR VPWR _2328_/A sky130_fd_sc_hd__and3_2
XFILLER_23_3 VGND VGND VPWR VPWR sky130_fd_sc_hd__fill_1
X_2153_ _2153_/A _2153_/B VGND VGND VPWR VPWR _2164_/B sky130_fd_sc_hd__xnor2_1
XFILLER_38_246 VGND VGND VPWR VPWR sky130_fd_sc_hd__decap_3
XFILLER_38_213 VGND VGND VPWR VPWR sky130_fd_sc_hd__decap_3
XFILLER_38_279 VGND VGND VPWR VPWR sky130_fd_sc_hd__decap_3
X_2084_ _2084_/A _2084_/B _2208_/A VGND VGND VPWR VPWR _2084_/X sky130_fd_sc_hd__and3_1
XTAP_TAPCELL_ROW_51_439 VGND VPWR sky130_fd_sc_hd__tapvpwrvgnd_1
XFILLER_21_113 VGND VGND VPWR VPWR sky130_fd_sc_hd__decap_3
XFILLER_21_179 VGND VGND VPWR VPWR sky130_fd_sc_hd__fill_2
X_1937_ _1932_/A _1932_/B _1930_/X VGND VGND VPWR VPWR _2014_/A sky130_fd_sc_hd__a21oi_1
X_1868_ _1868_/A _1868_/B VGND VGND VPWR VPWR _1943_/C sky130_fd_sc_hd__xnor2_1
X_1799_ _2249_/B _1886_/A _1799_/C VGND VGND VPWR VPWR _1799_/X sky130_fd_sc_hd__or3_1
XFILLER_29_279 VGND VGND VPWR VPWR sky130_fd_sc_hd__fill_1
XFILLER_29_246 VGND VGND VPWR VPWR sky130_fd_sc_hd__decap_3
XFILLER_52_271 VGND VGND VPWR VPWR sky130_fd_sc_hd__decap_3
XFILLER_16_65 VGND VGND VPWR VPWR sky130_fd_sc_hd__decap_3
XFILLER_8_106 VGND VGND VPWR VPWR sky130_fd_sc_hd__fill_2
XFILLER_8_139 VGND VGND VPWR VPWR sky130_fd_sc_hd__fill_1
XFILLER_32_75 VGND VGND VPWR VPWR sky130_fd_sc_hd__fill_1
XFILLER_4_312 VGND VGND VPWR VPWR sky130_fd_sc_hd__decap_3
XFILLER_4_301 VGND VGND VPWR VPWR sky130_fd_sc_hd__decap_3
XTAP_TAPCELL_ROW_7_172 VGND VPWR sky130_fd_sc_hd__tapvpwrvgnd_1
XFILLER_57_83 VGND VGND VPWR VPWR sky130_fd_sc_hd__decap_3
XFILLER_35_238 VGND VGND VPWR VPWR sky130_fd_sc_hd__decap_3
XFILLER_35_216 VGND VGND VPWR VPWR sky130_fd_sc_hd__decap_3
XFILLER_50_219 VGND VGND VPWR VPWR sky130_fd_sc_hd__fill_2
X_2771_ _2777_/CLK _2771_/D fanout47/X VGND VGND VPWR VPWR _2771_/Q sky130_fd_sc_hd__dfrtp_1
XFILLER_11_190 VGND VGND VPWR VPWR sky130_fd_sc_hd__decap_3
X_1722_ _1727_/A _1722_/B _1722_/C VGND VGND VPWR VPWR _1863_/A sky130_fd_sc_hd__nor3_1
X_1653_ _1653_/A _1653_/B _1653_/C VGND VGND VPWR VPWR _1654_/B sky130_fd_sc_hd__or3_1
XPHY_EDGE_ROW_9_Right_9 VGND VGND VPWR VPWR sky130_fd_sc_hd__decap_3
XFILLER_7_194 VGND VGND VPWR VPWR sky130_fd_sc_hd__decap_3
X_1584_ _1809_/A _1584_/B _1584_/C VGND VGND VPWR VPWR _1603_/A sky130_fd_sc_hd__or3_1
X_2205_ _1441_/A _1441_/B _2206_/A VGND VGND VPWR VPWR _2263_/A sky130_fd_sc_hd__a21oi_2
X_2136_ _2133_/X _2136_/B VGND VGND VPWR VPWR _2189_/B sky130_fd_sc_hd__nand2b_1
XFILLER_26_216 VGND VGND VPWR VPWR sky130_fd_sc_hd__decap_3
X_2067_ _2066_/A _2067_/B VGND VGND VPWR VPWR _2071_/A sky130_fd_sc_hd__and2b_1
XFILLER_19_290 VGND VGND VPWR VPWR sky130_fd_sc_hd__decap_3
XPHY_EDGE_ROW_14_Left_75 VGND VGND VPWR VPWR sky130_fd_sc_hd__decap_3
XFILLER_1_348 VGND VGND VPWR VPWR sky130_fd_sc_hd__decap_3
XFILLER_49_308 VGND VGND VPWR VPWR sky130_fd_sc_hd__decap_3
XTAP_TAPCELL_ROW_4_153 VGND VPWR sky130_fd_sc_hd__tapvpwrvgnd_1
XFILLER_57_352 VGND VGND VPWR VPWR sky130_fd_sc_hd__decap_3
XFILLER_17_216 VGND VGND VPWR VPWR sky130_fd_sc_hd__decap_3
XFILLER_27_75 VGND VGND VPWR VPWR sky130_fd_sc_hd__decap_3
XFILLER_25_293 VGND VGND VPWR VPWR sky130_fd_sc_hd__decap_3
XFILLER_25_271 VGND VGND VPWR VPWR sky130_fd_sc_hd__decap_3
XFILLER_43_96 VGND VGND VPWR VPWR sky130_fd_sc_hd__decap_3
XTAP_TAPCELL_ROW_10_188 VGND VPWR sky130_fd_sc_hd__tapvpwrvgnd_1
XFILLER_57_9 VGND VGND VPWR VPWR sky130_fd_sc_hd__decap_3
XFILLER_4_24 VGND VGND VPWR VPWR sky130_fd_sc_hd__decap_3
XFILLER_4_35 VGND VGND VPWR VPWR sky130_fd_sc_hd__decap_3
XFILLER_4_197 VGND VGND VPWR VPWR sky130_fd_sc_hd__decap_3
XFILLER_48_330 VGND VGND VPWR VPWR sky130_fd_sc_hd__decap_3
XFILLER_31_263 VGND VGND VPWR VPWR sky130_fd_sc_hd__decap_3
X_2754_ _2754_/A _2754_/B VGND VGND VPWR VPWR _2773_/D sky130_fd_sc_hd__xnor2_1
X_1705_ _1456_/Y _2264_/A _1824_/A _1907_/A VGND VGND VPWR VPWR _1843_/B sky130_fd_sc_hd__o22a_1
X_2685_ _2619_/X _2620_/Y _2669_/B VGND VGND VPWR VPWR _2685_/Y sky130_fd_sc_hd__a21oi_1
X_1636_ _1673_/A _1673_/B VGND VGND VPWR VPWR _1640_/B sky130_fd_sc_hd__nor2_1
X_1567_ _1567_/A _1567_/B VGND VGND VPWR VPWR _1596_/A sky130_fd_sc_hd__nand2_1
X_1498_ _2774_/Q _1824_/A VGND VGND VPWR VPWR _1498_/Y sky130_fd_sc_hd__nand2_1
XFILLER_58_138 VGND VGND VPWR VPWR sky130_fd_sc_hd__fill_2
XFILLER_58_127 VGND VGND VPWR VPWR sky130_fd_sc_hd__decap_3
XFILLER_39_352 VGND VGND VPWR VPWR sky130_fd_sc_hd__decap_3
XFILLER_54_300 VGND VGND VPWR VPWR sky130_fd_sc_hd__decap_3
X_2119_ _2356_/A _2100_/A _2171_/B VGND VGND VPWR VPWR _2168_/B sky130_fd_sc_hd__mux2_1
XTAP_TAPCELL_ROW_1_134 VGND VPWR sky130_fd_sc_hd__tapvpwrvgnd_1
XFILLER_54_333 VGND VGND VPWR VPWR sky130_fd_sc_hd__decap_3
Xfanout23 _1804_/A VGND VGND VPWR VPWR _1582_/A sky130_fd_sc_hd__buf_2
Xfanout34 _2766_/Q VGND VGND VPWR VPWR _2742_/A sky130_fd_sc_hd__buf_2
Xfanout45 input4/X VGND VGND VPWR VPWR _1442_/B sky130_fd_sc_hd__buf_2
XFILLER_22_241 VGND VGND VPWR VPWR sky130_fd_sc_hd__decap_3
XFILLER_22_274 VGND VGND VPWR VPWR sky130_fd_sc_hd__decap_3
XFILLER_13_44 VGND VGND VPWR VPWR sky130_fd_sc_hd__decap_3
XFILLER_13_99 VGND VGND VPWR VPWR sky130_fd_sc_hd__decap_3
XFILLER_49_149 VGND VGND VPWR VPWR sky130_fd_sc_hd__decap_3
XFILLER_38_41 VGND VGND VPWR VPWR sky130_fd_sc_hd__decap_3
XFILLER_57_160 VGND VGND VPWR VPWR sky130_fd_sc_hd__decap_3
XFILLER_38_85 VGND VGND VPWR VPWR sky130_fd_sc_hd__decap_3
XFILLER_54_73 VGND VGND VPWR VPWR sky130_fd_sc_hd__decap_3
XFILLER_54_62 VGND VGND VPWR VPWR sky130_fd_sc_hd__fill_2
XFILLER_13_230 VGND VGND VPWR VPWR sky130_fd_sc_hd__decap_3
XFILLER_13_285 VGND VGND VPWR VPWR sky130_fd_sc_hd__fill_2
XFILLER_9_267 VGND VGND VPWR VPWR sky130_fd_sc_hd__decap_3
X_2470_ _2473_/A _2498_/A VGND VGND VPWR VPWR _2471_/B sky130_fd_sc_hd__and2_1
XFILLER_55_6 VGND VGND VPWR VPWR sky130_fd_sc_hd__decap_3
X_1421_ _1421_/A _1421_/B VGND VGND VPWR VPWR _2084_/B sky130_fd_sc_hd__nand2_2
XFILLER_36_300 VGND VGND VPWR VPWR sky130_fd_sc_hd__decap_3
XFILLER_48_193 VGND VGND VPWR VPWR sky130_fd_sc_hd__decap_3
XFILLER_51_314 VGND VGND VPWR VPWR sky130_fd_sc_hd__decap_3
XFILLER_51_358 VGND VGND VPWR VPWR sky130_fd_sc_hd__decap_3
X_2737_ _2764_/Q _2739_/C VGND VGND VPWR VPWR _2764_/D sky130_fd_sc_hd__xor2_1
X_2668_ _2661_/S _2667_/Y _2657_/B VGND VGND VPWR VPWR _2668_/Y sky130_fd_sc_hd__a21oi_1
X_1619_ _1620_/A _1620_/B VGND VGND VPWR VPWR _1787_/B sky130_fd_sc_hd__nor2_1
XFILLER_59_18 VGND VGND VPWR VPWR sky130_fd_sc_hd__decap_3
X_2599_ _2524_/X _2592_/Y _2603_/A _2593_/A VGND VGND VPWR VPWR _2601_/B sky130_fd_sc_hd__a211oi_1
XTAP_TAPCELL_ROW_29_306 VGND VPWR sky130_fd_sc_hd__tapvpwrvgnd_1
XTAP_TAPCELL_ROW_37_350 VGND VPWR sky130_fd_sc_hd__tapvpwrvgnd_1
XFILLER_42_358 VGND VGND VPWR VPWR sky130_fd_sc_hd__decap_3
XTAP_TAPCELL_ROW_20_250 VGND VPWR sky130_fd_sc_hd__tapvpwrvgnd_1
XFILLER_10_288 VGND VGND VPWR VPWR sky130_fd_sc_hd__decap_3
XFILLER_10_299 VGND VGND VPWR VPWR sky130_fd_sc_hd__decap_3
XFILLER_6_248 VGND VGND VPWR VPWR sky130_fd_sc_hd__decap_3
XFILLER_6_237 VGND VGND VPWR VPWR sky130_fd_sc_hd__fill_1
XFILLER_49_84 VGND VGND VPWR VPWR sky130_fd_sc_hd__decap_3
XFILLER_37_108 VGND VGND VPWR VPWR sky130_fd_sc_hd__decap_3
XFILLER_1_36 VGND VGND VPWR VPWR sky130_fd_sc_hd__decap_3
XFILLER_1_69 VGND VGND VPWR VPWR sky130_fd_sc_hd__decap_3
XFILLER_18_344 VGND VGND VPWR VPWR sky130_fd_sc_hd__decap_3
XFILLER_60_122 VGND VGND VPWR VPWR sky130_fd_sc_hd__decap_3
XFILLER_60_100 VGND VGND VPWR VPWR sky130_fd_sc_hd__decap_3
XFILLER_33_314 VGND VGND VPWR VPWR sky130_fd_sc_hd__decap_3
X_1970_ _1970_/A _2034_/A VGND VGND VPWR VPWR _2037_/B sky130_fd_sc_hd__xor2_1
XFILLER_60_144 VGND VGND VPWR VPWR sky130_fd_sc_hd__decap_3
XTAP_TAPCELL_ROW_43_386 VGND VPWR sky130_fd_sc_hd__tapvpwrvgnd_1
X_2522_ _2522_/A _2522_/B VGND VGND VPWR VPWR _2537_/A sky130_fd_sc_hd__xnor2_2
XFILLER_53_3 VGND VGND VPWR VPWR sky130_fd_sc_hd__decap_3
XFILLER_5_281 VGND VGND VPWR VPWR sky130_fd_sc_hd__decap_3
XFILLER_5_270 VGND VGND VPWR VPWR sky130_fd_sc_hd__decap_3
X_2453_ _2453_/A _2453_/B _2456_/A VGND VGND VPWR VPWR _2454_/B sky130_fd_sc_hd__and3_1
X_1404_ _1411_/A _1410_/A VGND VGND VPWR VPWR _1586_/A sky130_fd_sc_hd__nand2_4
X_2384_ _2384_/A _2475_/A VGND VGND VPWR VPWR _2453_/B sky130_fd_sc_hd__nand2_1
Xinput2 rst_n VGND VGND VPWR VPWR input2/X sky130_fd_sc_hd__buf_1
XFILLER_28_119 VGND VGND VPWR VPWR sky130_fd_sc_hd__decap_3
XFILLER_36_141 VGND VGND VPWR VPWR sky130_fd_sc_hd__decap_3
XFILLER_36_130 VGND VGND VPWR VPWR sky130_fd_sc_hd__decap_3
XFILLER_51_100 VGND VGND VPWR VPWR sky130_fd_sc_hd__decap_3
XFILLER_24_303 VGND VGND VPWR VPWR sky130_fd_sc_hd__fill_1
XFILLER_51_122 VGND VGND VPWR VPWR sky130_fd_sc_hd__decap_3
XFILLER_10_56 VGND VGND VPWR VPWR sky130_fd_sc_hd__decap_3
XFILLER_59_222 VGND VGND VPWR VPWR sky130_fd_sc_hd__fill_2
XFILLER_59_255 VGND VGND VPWR VPWR sky130_fd_sc_hd__decap_3
XFILLER_19_119 VGND VGND VPWR VPWR sky130_fd_sc_hd__decap_3
XFILLER_19_108 VGND VGND VPWR VPWR sky130_fd_sc_hd__decap_3
XFILLER_59_299 VGND VGND VPWR VPWR sky130_fd_sc_hd__decap_3
XFILLER_15_303 VGND VGND VPWR VPWR sky130_fd_sc_hd__decap_3
XFILLER_35_64 VGND VGND VPWR VPWR sky130_fd_sc_hd__decap_3
XFILLER_42_166 VGND VGND VPWR VPWR sky130_fd_sc_hd__fill_2
XFILLER_35_86 VGND VGND VPWR VPWR sky130_fd_sc_hd__decap_3
XFILLER_30_306 VGND VGND VPWR VPWR sky130_fd_sc_hd__fill_2
XFILLER_30_339 VGND VGND VPWR VPWR sky130_fd_sc_hd__fill_1
XFILLER_51_63 VGND VGND VPWR VPWR sky130_fd_sc_hd__decap_3
XFILLER_51_52 VGND VGND VPWR VPWR sky130_fd_sc_hd__decap_3
XFILLER_51_41 VGND VGND VPWR VPWR sky130_fd_sc_hd__fill_1
XPHY_EDGE_ROW_2_Left_63 VGND VGND VPWR VPWR sky130_fd_sc_hd__decap_3
XFILLER_2_295 VGND VGND VPWR VPWR sky130_fd_sc_hd__decap_3
XFILLER_18_6 VGND VGND VPWR VPWR sky130_fd_sc_hd__decap_3
XFILLER_18_152 VGND VGND VPWR VPWR sky130_fd_sc_hd__decap_3
XFILLER_18_141 VGND VGND VPWR VPWR sky130_fd_sc_hd__decap_3
XFILLER_18_130 VGND VGND VPWR VPWR sky130_fd_sc_hd__decap_3
XFILLER_33_122 VGND VGND VPWR VPWR sky130_fd_sc_hd__fill_2
XFILLER_33_166 VGND VGND VPWR VPWR sky130_fd_sc_hd__fill_2
XFILLER_21_306 VGND VGND VPWR VPWR sky130_fd_sc_hd__decap_3
X_1953_ _2024_/A _2024_/B VGND VGND VPWR VPWR _1957_/A sky130_fd_sc_hd__nand2_1
X_1884_ _1885_/A _1885_/B VGND VGND VPWR VPWR _1884_/Y sky130_fd_sc_hd__nand2b_1
X_2505_ _2657_/A _2507_/A _2663_/A VGND VGND VPWR VPWR _2595_/A sky130_fd_sc_hd__a21oi_2
X_2436_ _2437_/A _2437_/B VGND VGND VPWR VPWR _2694_/A sky130_fd_sc_hd__or2_1
X_2367_ _2367_/A _2367_/B _2367_/C VGND VGND VPWR VPWR _2392_/A sky130_fd_sc_hd__and3_1
XFILLER_56_203 VGND VGND VPWR VPWR sky130_fd_sc_hd__decap_3
X_2298_ _2298_/A VGND VGND VPWR VPWR _2298_/Y sky130_fd_sc_hd__inv_2
XFILLER_56_247 VGND VGND VPWR VPWR sky130_fd_sc_hd__decap_3
XFILLER_56_225 VGND VGND VPWR VPWR sky130_fd_sc_hd__decap_3
XFILLER_24_166 VGND VGND VPWR VPWR sky130_fd_sc_hd__fill_2
XFILLER_12_339 VGND VGND VPWR VPWR sky130_fd_sc_hd__decap_3
XFILLER_21_55 VGND VGND VPWR VPWR sky130_fd_sc_hd__fill_1
XFILLER_21_99 VGND VGND VPWR VPWR sky130_fd_sc_hd__fill_1
XFILLER_47_203 VGND VGND VPWR VPWR sky130_fd_sc_hd__decap_3
XFILLER_47_214 VGND VGND VPWR VPWR sky130_fd_sc_hd__decap_3
XFILLER_47_247 VGND VGND VPWR VPWR sky130_fd_sc_hd__fill_1
XFILLER_46_85 VGND VGND VPWR VPWR sky130_fd_sc_hd__decap_3
XFILLER_15_122 VGND VGND VPWR VPWR sky130_fd_sc_hd__fill_1
XFILLER_15_166 VGND VGND VPWR VPWR sky130_fd_sc_hd__fill_2
XFILLER_15_155 VGND VGND VPWR VPWR sky130_fd_sc_hd__decap_3
XFILLER_7_310 VGND VGND VPWR VPWR sky130_fd_sc_hd__decap_3
XFILLER_7_24 VGND VGND VPWR VPWR sky130_fd_sc_hd__decap_3
XFILLER_7_57 VGND VGND VPWR VPWR sky130_fd_sc_hd__fill_2
X_2221_ _2221_/A _2221_/B VGND VGND VPWR VPWR _2267_/A sky130_fd_sc_hd__xnor2_2
X_2152_ _2152_/A _2159_/A _2152_/C VGND VGND VPWR VPWR _2203_/A sky130_fd_sc_hd__nand3_2
XFILLER_38_225 VGND VGND VPWR VPWR sky130_fd_sc_hd__decap_3
X_2083_ _1421_/A _1421_/B _2732_/A VGND VGND VPWR VPWR _2253_/A sky130_fd_sc_hd__a21bo_1
XFILLER_53_206 VGND VGND VPWR VPWR sky130_fd_sc_hd__decap_3
XFILLER_21_125 VGND VGND VPWR VPWR sky130_fd_sc_hd__fill_1
X_1936_ _1938_/A _1938_/B VGND VGND VPWR VPWR _1940_/A sky130_fd_sc_hd__and2b_1
X_1867_ _1941_/A _1941_/B VGND VGND VPWR VPWR _1943_/B sky130_fd_sc_hd__and2_1
X_1798_ _2283_/B _1797_/X _1878_/A VGND VGND VPWR VPWR _1799_/C sky130_fd_sc_hd__a21o_1
X_2419_ _2460_/A _2653_/B VGND VGND VPWR VPWR _2419_/Y sky130_fd_sc_hd__nand2_1
XFILLER_29_203 VGND VGND VPWR VPWR sky130_fd_sc_hd__decap_3
XFILLER_29_225 VGND VGND VPWR VPWR sky130_fd_sc_hd__decap_3
XFILLER_29_258 VGND VGND VPWR VPWR sky130_fd_sc_hd__decap_3
XFILLER_44_239 VGND VGND VPWR VPWR sky130_fd_sc_hd__decap_3
XFILLER_12_103 VGND VGND VPWR VPWR sky130_fd_sc_hd__decap_3
XFILLER_52_283 VGND VGND VPWR VPWR sky130_fd_sc_hd__decap_3
XFILLER_16_88 VGND VGND VPWR VPWR sky130_fd_sc_hd__decap_3
XFILLER_8_118 VGND VGND VPWR VPWR sky130_fd_sc_hd__decap_3
XFILLER_32_65 VGND VGND VPWR VPWR sky130_fd_sc_hd__decap_3
XFILLER_4_357 VGND VGND VPWR VPWR sky130_fd_sc_hd__fill_1
XTAP_TAPCELL_ROW_7_173 VGND VPWR sky130_fd_sc_hd__tapvpwrvgnd_1
XFILLER_57_51 VGND VGND VPWR VPWR sky130_fd_sc_hd__decap_3
XFILLER_57_95 VGND VGND VPWR VPWR sky130_fd_sc_hd__decap_3
XFILLER_28_291 VGND VGND VPWR VPWR sky130_fd_sc_hd__decap_3
XFILLER_43_261 VGND VGND VPWR VPWR sky130_fd_sc_hd__decap_3
X_2770_ _2777_/CLK _2770_/D fanout47/X VGND VGND VPWR VPWR _2770_/Q sky130_fd_sc_hd__dfrtp_4
X_1721_ _1721_/A _1721_/B VGND VGND VPWR VPWR _1722_/C sky130_fd_sc_hd__xnor2_1
XFILLER_7_140 VGND VGND VPWR VPWR sky130_fd_sc_hd__decap_3
X_1652_ _1653_/A _1653_/B _1653_/C VGND VGND VPWR VPWR _1654_/A sky130_fd_sc_hd__o21ai_1
X_1583_ _2084_/B _2284_/A VGND VGND VPWR VPWR _1584_/C sky130_fd_sc_hd__xnor2_1
XFILLER_58_309 VGND VGND VPWR VPWR sky130_fd_sc_hd__decap_3
X_2204_ _2203_/A _2203_/C _2203_/B VGND VGND VPWR VPWR _2212_/B sky130_fd_sc_hd__a21o_1
X_2135_ _2067_/B _2132_/Y _2131_/Y _2131_/A VGND VGND VPWR VPWR _2136_/B sky130_fd_sc_hd__a211o_1
XFILLER_26_228 VGND VGND VPWR VPWR sky130_fd_sc_hd__decap_3
X_2066_ _2066_/A _2066_/B _2066_/C VGND VGND VPWR VPWR _2067_/B sky130_fd_sc_hd__or3_1
XFILLER_26_239 VGND VGND VPWR VPWR sky130_fd_sc_hd__decap_3
XFILLER_41_209 VGND VGND VPWR VPWR sky130_fd_sc_hd__decap_3
X_1919_ _2045_/B _1985_/B VGND VGND VPWR VPWR _1968_/A sky130_fd_sc_hd__nor2_1
XFILLER_57_320 VGND VGND VPWR VPWR sky130_fd_sc_hd__decap_3
XTAP_TAPCELL_ROW_4_154 VGND VPWR sky130_fd_sc_hd__tapvpwrvgnd_1
XFILLER_27_54 VGND VGND VPWR VPWR sky130_fd_sc_hd__fill_2
XFILLER_17_228 VGND VGND VPWR VPWR sky130_fd_sc_hd__decap_3
XFILLER_27_87 VGND VGND VPWR VPWR sky130_fd_sc_hd__decap_3
XFILLER_32_209 VGND VGND VPWR VPWR sky130_fd_sc_hd__fill_1
XFILLER_25_261 VGND VGND VPWR VPWR sky130_fd_sc_hd__decap_3
XFILLER_40_275 VGND VGND VPWR VPWR sky130_fd_sc_hd__decap_3
XFILLER_40_264 VGND VGND VPWR VPWR sky130_fd_sc_hd__fill_1
XTAP_TAPCELL_ROW_10_189 VGND VPWR sky130_fd_sc_hd__tapvpwrvgnd_1
XFILLER_4_121 VGND VGND VPWR VPWR sky130_fd_sc_hd__decap_3
XFILLER_4_187 VGND VGND VPWR VPWR sky130_fd_sc_hd__decap_3
XPHY_EDGE_ROW_31_Left_92 VGND VGND VPWR VPWR sky130_fd_sc_hd__decap_3
XFILLER_48_342 VGND VGND VPWR VPWR sky130_fd_sc_hd__decap_3
XFILLER_31_231 VGND VGND VPWR VPWR sky130_fd_sc_hd__decap_3
XFILLER_31_275 VGND VGND VPWR VPWR sky130_fd_sc_hd__decap_3
X_2753_ _2754_/B _2753_/B VGND VGND VPWR VPWR _2772_/D sky130_fd_sc_hd__and2_1
X_1704_ _2045_/B _1704_/B VGND VGND VPWR VPWR _1907_/A sky130_fd_sc_hd__nor2_1
X_2684_ input6/X _2684_/B VGND VGND VPWR VPWR uo_out[1] sky130_fd_sc_hd__xor2_4
X_1635_ _1671_/A _1635_/B VGND VGND VPWR VPWR _1673_/B sky130_fd_sc_hd__xnor2_1
X_1566_ _1565_/B _1566_/B VGND VGND VPWR VPWR _1567_/B sky130_fd_sc_hd__nand2b_1
X_1497_ _1683_/A _1824_/A _2264_/A VGND VGND VPWR VPWR _1499_/B sky130_fd_sc_hd__o21ai_1
XFILLER_54_312 VGND VGND VPWR VPWR sky130_fd_sc_hd__decap_3
X_2118_ _2774_/Q _2336_/A VGND VGND VPWR VPWR _2168_/A sky130_fd_sc_hd__nand2_1
XTAP_TAPCELL_ROW_1_135 VGND VPWR sky130_fd_sc_hd__tapvpwrvgnd_1
XFILLER_54_345 VGND VGND VPWR VPWR sky130_fd_sc_hd__decap_3
XFILLER_14_209 VGND VGND VPWR VPWR sky130_fd_sc_hd__decap_3
X_2049_ _2100_/A _2048_/B _2048_/A VGND VGND VPWR VPWR _2051_/A sky130_fd_sc_hd__a21boi_1
Xfanout24 _1587_/A VGND VGND VPWR VPWR _1886_/A sky130_fd_sc_hd__buf_2
Xfanout35 _2084_/A VGND VGND VPWR VPWR _2735_/A sky130_fd_sc_hd__buf_2
Xfanout46 input3/X VGND VGND VPWR VPWR _1473_/B sky130_fd_sc_hd__buf_2
XFILLER_22_286 VGND VGND VPWR VPWR sky130_fd_sc_hd__decap_3
XFILLER_22_253 VGND VGND VPWR VPWR sky130_fd_sc_hd__decap_3
XFILLER_13_78 VGND VGND VPWR VPWR sky130_fd_sc_hd__decap_3
XFILLER_49_106 VGND VGND VPWR VPWR sky130_fd_sc_hd__decap_3
XFILLER_38_97 VGND VGND VPWR VPWR sky130_fd_sc_hd__decap_3
XFILLER_38_64 VGND VGND VPWR VPWR sky130_fd_sc_hd__decap_3
XFILLER_57_194 VGND VGND VPWR VPWR sky130_fd_sc_hd__decap_3
XFILLER_57_172 VGND VGND VPWR VPWR sky130_fd_sc_hd__decap_3
XFILLER_45_345 VGND VGND VPWR VPWR sky130_fd_sc_hd__decap_3
XFILLER_54_41 VGND VGND VPWR VPWR sky130_fd_sc_hd__decap_3
XFILLER_60_337 VGND VGND VPWR VPWR sky130_fd_sc_hd__decap_3
XFILLER_60_315 VGND VGND VPWR VPWR sky130_fd_sc_hd__decap_3
XFILLER_54_85 VGND VGND VPWR VPWR sky130_fd_sc_hd__decap_3
XFILLER_13_264 VGND VGND VPWR VPWR sky130_fd_sc_hd__decap_3
XFILLER_9_213 VGND VGND VPWR VPWR sky130_fd_sc_hd__decap_3
XTAP_TAPCELL_ROW_23_270 VGND VPWR sky130_fd_sc_hd__tapvpwrvgnd_1
XFILLER_9_279 VGND VGND VPWR VPWR sky130_fd_sc_hd__fill_1
X_1420_ _1421_/A _1421_/B VGND VGND VPWR VPWR _1804_/A sky130_fd_sc_hd__and2_1
XFILLER_48_6 VGND VGND VPWR VPWR sky130_fd_sc_hd__decap_3
XFILLER_0_190 VGND VGND VPWR VPWR sky130_fd_sc_hd__decap_3
XFILLER_48_150 VGND VGND VPWR VPWR sky130_fd_sc_hd__decap_3
XFILLER_48_172 VGND VGND VPWR VPWR sky130_fd_sc_hd__decap_3
XFILLER_36_334 VGND VGND VPWR VPWR sky130_fd_sc_hd__decap_3
XFILLER_36_312 VGND VGND VPWR VPWR sky130_fd_sc_hd__decap_3
XFILLER_36_356 VGND VGND VPWR VPWR sky130_fd_sc_hd__decap_3
XFILLER_51_337 VGND VGND VPWR VPWR sky130_fd_sc_hd__decap_3
XFILLER_51_326 VGND VGND VPWR VPWR sky130_fd_sc_hd__decap_3
X_2736_ _2736_/A _2739_/C VGND VGND VPWR VPWR _2763_/D sky130_fd_sc_hd__nor2_1
X_2667_ _2649_/A _2649_/B _2638_/C _2660_/A VGND VGND VPWR VPWR _2667_/Y sky130_fd_sc_hd__o2bb2ai_1
X_1618_ _1618_/A _1618_/B VGND VGND VPWR VPWR _1620_/B sky130_fd_sc_hd__xnor2_1
X_2598_ _2657_/A _2596_/X _2597_/Y VGND VGND VPWR VPWR _2598_/X sky130_fd_sc_hd__a21o_1
X_1549_ _1549_/A _1549_/B VGND VGND VPWR VPWR _1620_/A sky130_fd_sc_hd__xnor2_1
XTAP_TAPCELL_ROW_29_307 VGND VPWR sky130_fd_sc_hd__tapvpwrvgnd_1
XFILLER_46_109 VGND VGND VPWR VPWR sky130_fd_sc_hd__decap_3
XFILLER_39_161 VGND VGND VPWR VPWR sky130_fd_sc_hd__decap_3
XFILLER_54_120 VGND VGND VPWR VPWR sky130_fd_sc_hd__decap_3
XFILLER_39_194 VGND VGND VPWR VPWR sky130_fd_sc_hd__decap_3
XFILLER_39_172 VGND VGND VPWR VPWR sky130_fd_sc_hd__decap_3
XFILLER_27_334 VGND VGND VPWR VPWR sky130_fd_sc_hd__fill_2
XFILLER_27_356 VGND VGND VPWR VPWR sky130_fd_sc_hd__fill_1
XTAP_TAPCELL_ROW_37_351 VGND VPWR sky130_fd_sc_hd__tapvpwrvgnd_1
XFILLER_54_175 VGND VGND VPWR VPWR sky130_fd_sc_hd__decap_3
XFILLER_42_337 VGND VGND VPWR VPWR sky130_fd_sc_hd__decap_3
XFILLER_42_315 VGND VGND VPWR VPWR sky130_fd_sc_hd__decap_3
XFILLER_24_66 VGND VGND VPWR VPWR sky130_fd_sc_hd__decap_3
XFILLER_10_212 VGND VGND VPWR VPWR sky130_fd_sc_hd__decap_3
XFILLER_24_88 VGND VGND VPWR VPWR sky130_fd_sc_hd__decap_3
XFILLER_10_256 VGND VGND VPWR VPWR sky130_fd_sc_hd__decap_3
XTAP_TAPCELL_ROW_20_251 VGND VPWR sky130_fd_sc_hd__tapvpwrvgnd_1
XFILLER_40_43 VGND VGND VPWR VPWR sky130_fd_sc_hd__decap_3
XFILLER_40_21 VGND VGND VPWR VPWR sky130_fd_sc_hd__decap_3
XFILLER_49_30 VGND VGND VPWR VPWR sky130_fd_sc_hd__decap_3
XFILLER_1_15 VGND VGND VPWR VPWR sky130_fd_sc_hd__decap_3
XFILLER_1_48 VGND VGND VPWR VPWR sky130_fd_sc_hd__decap_3
XFILLER_45_131 VGND VGND VPWR VPWR sky130_fd_sc_hd__decap_3
XFILLER_18_356 VGND VGND VPWR VPWR sky130_fd_sc_hd__decap_3
XFILLER_45_175 VGND VGND VPWR VPWR sky130_fd_sc_hd__decap_3
XFILLER_33_326 VGND VGND VPWR VPWR sky130_fd_sc_hd__decap_3
XFILLER_60_134 VGND VGND VPWR VPWR sky130_fd_sc_hd__decap_3
XFILLER_45_197 VGND VGND VPWR VPWR sky130_fd_sc_hd__decap_3
XFILLER_60_178 VGND VGND VPWR VPWR sky130_fd_sc_hd__decap_3
XFILLER_60_156 VGND VGND VPWR VPWR sky130_fd_sc_hd__decap_3
XTAP_TAPCELL_ROW_43_387 VGND VPWR sky130_fd_sc_hd__tapvpwrvgnd_1
X_2521_ _2521_/A _2521_/B VGND VGND VPWR VPWR _2591_/A sky130_fd_sc_hd__nor2_1
X_2452_ _2777_/Q _2429_/Y _2701_/A VGND VGND VPWR VPWR _2457_/A sky130_fd_sc_hd__a21o_1
XFILLER_46_3 VGND VGND VPWR VPWR sky130_fd_sc_hd__decap_3
X_1403_ _2767_/Q _1438_/B _1416_/D _1414_/A _1410_/A VGND VGND VPWR VPWR _1999_/A
+ sky130_fd_sc_hd__o311a_2
X_2383_ _2383_/A _2383_/B VGND VGND VPWR VPWR _2475_/A sky130_fd_sc_hd__or2_2
XPHY_EDGE_ROW_18_Right_18 VGND VGND VPWR VPWR sky130_fd_sc_hd__decap_3
Xinput3 ui_in[0] VGND VGND VPWR VPWR input3/X sky130_fd_sc_hd__buf_1
XFILLER_36_153 VGND VGND VPWR VPWR sky130_fd_sc_hd__decap_3
XTAP_TAPCELL_ROW_34_332 VGND VPWR sky130_fd_sc_hd__tapvpwrvgnd_1
XPHY_EDGE_ROW_27_Right_27 VGND VGND VPWR VPWR sky130_fd_sc_hd__decap_3
XFILLER_51_145 VGND VGND VPWR VPWR sky130_fd_sc_hd__decap_3
X_2719_ _2721_/B _2719_/B VGND VGND VPWR VPWR _2719_/X sky130_fd_sc_hd__or2_1
XFILLER_10_13 VGND VGND VPWR VPWR sky130_fd_sc_hd__decap_3
XFILLER_10_35 VGND VGND VPWR VPWR sky130_fd_sc_hd__decap_3
XFILLER_10_79 VGND VGND VPWR VPWR sky130_fd_sc_hd__decap_3
XPHY_EDGE_ROW_36_Right_36 VGND VGND VPWR VPWR sky130_fd_sc_hd__decap_3
XFILLER_59_234 VGND VGND VPWR VPWR sky130_fd_sc_hd__decap_3
XFILLER_59_267 VGND VGND VPWR VPWR sky130_fd_sc_hd__decap_3
XPHY_EDGE_ROW_45_Right_45 VGND VGND VPWR VPWR sky130_fd_sc_hd__decap_3
XFILLER_42_112 VGND VGND VPWR VPWR sky130_fd_sc_hd__fill_1
XFILLER_35_43 VGND VGND VPWR VPWR sky130_fd_sc_hd__decap_3
XFILLER_35_21 VGND VGND VPWR VPWR sky130_fd_sc_hd__decap_3
XFILLER_27_175 VGND VGND VPWR VPWR sky130_fd_sc_hd__decap_3
XFILLER_15_315 VGND VGND VPWR VPWR sky130_fd_sc_hd__decap_3
XFILLER_42_123 VGND VGND VPWR VPWR sky130_fd_sc_hd__decap_3
XFILLER_15_337 VGND VGND VPWR VPWR sky130_fd_sc_hd__fill_2
XFILLER_35_98 VGND VGND VPWR VPWR sky130_fd_sc_hd__decap_3
XFILLER_30_318 VGND VGND VPWR VPWR sky130_fd_sc_hd__decap_3
XTAP_TAPCELL_ROW_40_368 VGND VPWR sky130_fd_sc_hd__tapvpwrvgnd_1
XFILLER_51_86 VGND VGND VPWR VPWR sky130_fd_sc_hd__decap_3
XFILLER_51_75 VGND VGND VPWR VPWR sky130_fd_sc_hd__decap_3
XPHY_EDGE_ROW_54_Right_54 VGND VGND VPWR VPWR sky130_fd_sc_hd__decap_3
XFILLER_32_9 VGND VGND VPWR VPWR sky130_fd_sc_hd__decap_3
XFILLER_33_101 VGND VGND VPWR VPWR sky130_fd_sc_hd__decap_3
XFILLER_33_145 VGND VGND VPWR VPWR sky130_fd_sc_hd__decap_3
XFILLER_33_134 VGND VGND VPWR VPWR sky130_fd_sc_hd__decap_3
XFILLER_18_197 VGND VGND VPWR VPWR sky130_fd_sc_hd__decap_3
XFILLER_33_178 VGND VGND VPWR VPWR sky130_fd_sc_hd__decap_3
X_1952_ _1972_/A _2026_/B _1876_/Y VGND VGND VPWR VPWR _2024_/B sky130_fd_sc_hd__a21oi_1
XFILLER_21_329 VGND VGND VPWR VPWR sky130_fd_sc_hd__decap_3
X_1883_ _2084_/B _1883_/B VGND VGND VPWR VPWR _1885_/B sky130_fd_sc_hd__xnor2_1
X_2504_ _2522_/A _2501_/X _2502_/X _2503_/Y VGND VGND VPWR VPWR _2507_/A sky130_fd_sc_hd__a211o_1
X_2435_ _2435_/A _2435_/B VGND VGND VPWR VPWR _2437_/B sky130_fd_sc_hd__or2_1
X_2366_ _2398_/A _2398_/B _2280_/X _2308_/X VGND VGND VPWR VPWR _2367_/C sky130_fd_sc_hd__a211o_1
X_2297_ _2297_/A _2297_/B _2297_/C VGND VGND VPWR VPWR _2298_/A sky130_fd_sc_hd__and3_1
XFILLER_56_259 VGND VGND VPWR VPWR sky130_fd_sc_hd__decap_3
XFILLER_24_112 VGND VGND VPWR VPWR sky130_fd_sc_hd__decap_3
XFILLER_12_318 VGND VGND VPWR VPWR sky130_fd_sc_hd__decap_3
XFILLER_24_178 VGND VGND VPWR VPWR sky130_fd_sc_hd__decap_3
XFILLER_21_78 VGND VGND VPWR VPWR sky130_fd_sc_hd__decap_3
XFILLER_21_67 VGND VGND VPWR VPWR sky130_fd_sc_hd__fill_2
XFILLER_55_270 VGND VGND VPWR VPWR sky130_fd_sc_hd__decap_3
XFILLER_46_53 VGND VGND VPWR VPWR sky130_fd_sc_hd__decap_3
XFILLER_55_281 VGND VGND VPWR VPWR sky130_fd_sc_hd__decap_3
XFILLER_46_97 VGND VGND VPWR VPWR sky130_fd_sc_hd__decap_3
XFILLER_30_126 VGND VGND VPWR VPWR sky130_fd_sc_hd__fill_1
XFILLER_11_351 VGND VGND VPWR VPWR sky130_fd_sc_hd__decap_3
XFILLER_7_36 VGND VGND VPWR VPWR sky130_fd_sc_hd__decap_3
XFILLER_7_333 VGND VGND VPWR VPWR sky130_fd_sc_hd__decap_3
XFILLER_7_355 VGND VGND VPWR VPWR sky130_fd_sc_hd__decap_3
X_2220_ _2221_/A _2221_/B VGND VGND VPWR VPWR _2220_/Y sky130_fd_sc_hd__nand2_1
XFILLER_30_6 VGND VGND VPWR VPWR sky130_fd_sc_hd__decap_3
X_2151_ _2150_/B _2150_/C _2283_/A VGND VGND VPWR VPWR _2152_/C sky130_fd_sc_hd__a21bo_1
XFILLER_38_237 VGND VGND VPWR VPWR sky130_fd_sc_hd__decap_3
XFILLER_38_204 VGND VGND VPWR VPWR sky130_fd_sc_hd__decap_3
X_2082_ _1398_/Y _1415_/Y _1416_/X _2762_/Q VGND VGND VPWR VPWR _2208_/A sky130_fd_sc_hd__o211a_1
XFILLER_38_259 VGND VGND VPWR VPWR sky130_fd_sc_hd__fill_1
XFILLER_46_270 VGND VGND VPWR VPWR sky130_fd_sc_hd__decap_3
X_1935_ _1935_/A _1935_/B VGND VGND VPWR VPWR _1938_/B sky130_fd_sc_hd__xnor2_1
XFILLER_21_159 VGND VGND VPWR VPWR sky130_fd_sc_hd__decap_3
X_1866_ _1866_/A _1866_/B VGND VGND VPWR VPWR _1941_/B sky130_fd_sc_hd__xnor2_1
X_1797_ _2762_/Q _2021_/A VGND VGND VPWR VPWR _1797_/X sky130_fd_sc_hd__or2_1
X_2418_ _2653_/B VGND VGND VPWR VPWR _2512_/A sky130_fd_sc_hd__inv_2
X_2349_ _2732_/A _1899_/B _2084_/A VGND VGND VPWR VPWR _2350_/B sky130_fd_sc_hd__o21a_1
XFILLER_29_237 VGND VGND VPWR VPWR sky130_fd_sc_hd__decap_3
XFILLER_37_281 VGND VGND VPWR VPWR sky130_fd_sc_hd__decap_3
XFILLER_37_270 VGND VGND VPWR VPWR sky130_fd_sc_hd__decap_3
XPHY_EDGE_ROW_0_Right_0 VGND VGND VPWR VPWR sky130_fd_sc_hd__decap_3
XFILLER_52_262 VGND VGND VPWR VPWR sky130_fd_sc_hd__decap_3
XFILLER_52_240 VGND VGND VPWR VPWR sky130_fd_sc_hd__decap_3
XFILLER_16_56 VGND VGND VPWR VPWR sky130_fd_sc_hd__decap_3
XFILLER_52_295 VGND VGND VPWR VPWR sky130_fd_sc_hd__decap_3
XFILLER_12_137 VGND VGND VPWR VPWR sky130_fd_sc_hd__decap_3
XTAP_TAPCELL_ROW_50_430 VGND VPWR sky130_fd_sc_hd__tapvpwrvgnd_1
XFILLER_32_88 VGND VGND VPWR VPWR sky130_fd_sc_hd__fill_1
XFILLER_20_170 VGND VGND VPWR VPWR sky130_fd_sc_hd__decap_3
XFILLER_4_325 VGND VGND VPWR VPWR sky130_fd_sc_hd__decap_3
XFILLER_32_99 VGND VGND VPWR VPWR sky130_fd_sc_hd__decap_3
XTAP_TAPCELL_ROW_7_174 VGND VPWR sky130_fd_sc_hd__tapvpwrvgnd_1
XFILLER_57_30 VGND VGND VPWR VPWR sky130_fd_sc_hd__decap_3
XFILLER_57_74 VGND VGND VPWR VPWR sky130_fd_sc_hd__decap_3
XFILLER_57_63 VGND VGND VPWR VPWR sky130_fd_sc_hd__fill_2
XFILLER_35_207 VGND VGND VPWR VPWR sky130_fd_sc_hd__decap_3
XFILLER_43_284 VGND VGND VPWR VPWR sky130_fd_sc_hd__decap_3
XFILLER_11_181 VGND VGND VPWR VPWR sky130_fd_sc_hd__decap_3
X_1720_ _1720_/A _1720_/B VGND VGND VPWR VPWR _1721_/B sky130_fd_sc_hd__xnor2_1
X_1651_ _1651_/A _1651_/B VGND VGND VPWR VPWR _1653_/C sky130_fd_sc_hd__xnor2_1
XPHY_EDGE_ROW_44_Left_105 VGND VGND VPWR VPWR sky130_fd_sc_hd__decap_3
XFILLER_7_185 VGND VGND VPWR VPWR sky130_fd_sc_hd__decap_3
X_1582_ _1582_/A _2284_/A VGND VGND VPWR VPWR _1890_/A sky130_fd_sc_hd__nor2_1
X_2203_ _2203_/A _2203_/B _2203_/C VGND VGND VPWR VPWR _2213_/A sky130_fd_sc_hd__nand3_1
X_2134_ _2130_/A _2130_/B _2128_/X VGND VGND VPWR VPWR _2189_/A sky130_fd_sc_hd__a21o_1
XPHY_EDGE_ROW_53_Left_114 VGND VGND VPWR VPWR sky130_fd_sc_hd__decap_3
X_2065_ _2065_/A _2065_/B VGND VGND VPWR VPWR _2066_/C sky130_fd_sc_hd__xnor2_1
XFILLER_34_240 VGND VGND VPWR VPWR sky130_fd_sc_hd__decap_3
X_1918_ _2441_/A _2033_/A VGND VGND VPWR VPWR _2054_/A sky130_fd_sc_hd__nor2_1
X_1849_ _1849_/A _1849_/B VGND VGND VPWR VPWR _1851_/C sky130_fd_sc_hd__xnor2_1
XFILLER_1_306 VGND VGND VPWR VPWR sky130_fd_sc_hd__fill_2
XFILLER_1_328 VGND VGND VPWR VPWR sky130_fd_sc_hd__fill_1
XTAP_TAPCELL_ROW_4_155 VGND VPWR sky130_fd_sc_hd__tapvpwrvgnd_1
XFILLER_57_343 VGND VGND VPWR VPWR sky130_fd_sc_hd__decap_3
XFILLER_57_332 VGND VGND VPWR VPWR sky130_fd_sc_hd__decap_3
XFILLER_27_22 VGND VGND VPWR VPWR sky130_fd_sc_hd__decap_3
XFILLER_17_207 VGND VGND VPWR VPWR sky130_fd_sc_hd__decap_3
XFILLER_27_66 VGND VGND VPWR VPWR sky130_fd_sc_hd__decap_3
XFILLER_27_99 VGND VGND VPWR VPWR sky130_fd_sc_hd__decap_3
XFILLER_25_240 VGND VGND VPWR VPWR sky130_fd_sc_hd__decap_3
XFILLER_43_21 VGND VGND VPWR VPWR sky130_fd_sc_hd__decap_3
XFILLER_43_65 VGND VGND VPWR VPWR sky130_fd_sc_hd__decap_3
XFILLER_43_43 VGND VGND VPWR VPWR sky130_fd_sc_hd__decap_3
XFILLER_40_221 VGND VGND VPWR VPWR sky130_fd_sc_hd__decap_3
XFILLER_4_133 VGND VGND VPWR VPWR sky130_fd_sc_hd__decap_3
XFILLER_4_100 VGND VGND VPWR VPWR sky130_fd_sc_hd__fill_2
XFILLER_4_15 VGND VGND VPWR VPWR sky130_fd_sc_hd__decap_3
XFILLER_4_144 VGND VGND VPWR VPWR sky130_fd_sc_hd__decap_3
XFILLER_48_321 VGND VGND VPWR VPWR sky130_fd_sc_hd__decap_3
XFILLER_48_354 VGND VGND VPWR VPWR sky130_fd_sc_hd__decap_3
XFILLER_16_251 VGND VGND VPWR VPWR sky130_fd_sc_hd__fill_1
XFILLER_31_210 VGND VGND VPWR VPWR sky130_fd_sc_hd__decap_3
XFILLER_16_284 VGND VGND VPWR VPWR sky130_fd_sc_hd__decap_3
XFILLER_16_262 VGND VGND VPWR VPWR sky130_fd_sc_hd__fill_2
XFILLER_31_243 VGND VGND VPWR VPWR sky130_fd_sc_hd__decap_3
XFILLER_16_295 VGND VGND VPWR VPWR sky130_fd_sc_hd__decap_3
XFILLER_31_254 VGND VGND VPWR VPWR sky130_fd_sc_hd__decap_3
X_2752_ _2772_/Q _2752_/B VGND VGND VPWR VPWR _2753_/B sky130_fd_sc_hd__or2_1
X_1703_ _2222_/A _1703_/B VGND VGND VPWR VPWR _1713_/A sky130_fd_sc_hd__or2_1
X_2683_ _2672_/X _2680_/Y _2682_/Y _2696_/A VGND VGND VPWR VPWR _2684_/B sky130_fd_sc_hd__o31a_2
X_1634_ _1640_/A _1634_/B VGND VGND VPWR VPWR _1673_/A sky130_fd_sc_hd__or2_1
X_1565_ _1566_/B _1565_/B VGND VGND VPWR VPWR _1567_/A sky130_fd_sc_hd__nand2b_1
X_1496_ _2057_/A _2219_/B VGND VGND VPWR VPWR _1824_/A sky130_fd_sc_hd__nor2_2
XFILLER_39_343 VGND VGND VPWR VPWR sky130_fd_sc_hd__decap_3
XFILLER_39_332 VGND VGND VPWR VPWR sky130_fd_sc_hd__decap_3
X_2117_ _2356_/A _2171_/B VGND VGND VPWR VPWR _2117_/Y sky130_fd_sc_hd__nor2_1
XTAP_TAPCELL_ROW_1_136 VGND VPWR sky130_fd_sc_hd__tapvpwrvgnd_1
XFILLER_54_324 VGND VGND VPWR VPWR sky130_fd_sc_hd__decap_3
X_2048_ _2048_/A _2048_/B VGND VGND VPWR VPWR _2171_/A sky130_fd_sc_hd__nand2_1
XFILLER_54_357 VGND VGND VPWR VPWR sky130_fd_sc_hd__decap_3
Xfanout14 _2598_/X VGND VGND VPWR VPWR _2627_/A sky130_fd_sc_hd__clkbuf_2
Xfanout25 _1985_/B VGND VGND VPWR VPWR _2356_/A sky130_fd_sc_hd__clkbuf_4
Xfanout36 _2021_/A VGND VGND VPWR VPWR _2084_/A sky130_fd_sc_hd__dlymetal6s2s_1
Xfanout47 input2/X VGND VGND VPWR VPWR fanout47/X sky130_fd_sc_hd__clkbuf_4
XFILLER_13_24 VGND VGND VPWR VPWR sky130_fd_sc_hd__decap_3
XFILLER_22_265 VGND VGND VPWR VPWR sky130_fd_sc_hd__decap_3
XFILLER_13_35 VGND VGND VPWR VPWR sky130_fd_sc_hd__decap_3
XFILLER_13_57 VGND VGND VPWR VPWR sky130_fd_sc_hd__decap_3
XFILLER_22_298 VGND VGND VPWR VPWR sky130_fd_sc_hd__decap_3
XFILLER_8_6 VGND VGND VPWR VPWR sky130_fd_sc_hd__decap_3
XFILLER_1_158 VGND VGND VPWR VPWR sky130_fd_sc_hd__fill_1
XFILLER_49_129 VGND VGND VPWR VPWR sky130_fd_sc_hd__decap_3
XFILLER_38_21 VGND VGND VPWR VPWR sky130_fd_sc_hd__fill_2
XFILLER_57_184 VGND VGND VPWR VPWR sky130_fd_sc_hd__fill_1
XFILLER_45_335 VGND VGND VPWR VPWR sky130_fd_sc_hd__fill_1
XFILLER_45_357 VGND VGND VPWR VPWR sky130_fd_sc_hd__decap_3
XFILLER_60_327 VGND VGND VPWR VPWR sky130_fd_sc_hd__decap_3
XFILLER_60_305 VGND VGND VPWR VPWR sky130_fd_sc_hd__decap_3
XFILLER_54_53 VGND VGND VPWR VPWR sky130_fd_sc_hd__decap_3
XFILLER_13_243 VGND VGND VPWR VPWR sky130_fd_sc_hd__fill_2
XFILLER_60_349 VGND VGND VPWR VPWR sky130_fd_sc_hd__decap_3
XFILLER_54_97 VGND VGND VPWR VPWR sky130_fd_sc_hd__decap_3
XTAP_TAPCELL_ROW_23_271 VGND VPWR sky130_fd_sc_hd__tapvpwrvgnd_1
XFILLER_48_184 VGND VGND VPWR VPWR sky130_fd_sc_hd__decap_3
XFILLER_36_346 VGND VGND VPWR VPWR sky130_fd_sc_hd__fill_1
XFILLER_51_305 VGND VGND VPWR VPWR sky130_fd_sc_hd__decap_3
XFILLER_51_349 VGND VGND VPWR VPWR sky130_fd_sc_hd__decap_3
X_2735_ _2735_/A _2735_/B VGND VGND VPWR VPWR _2739_/C sky130_fd_sc_hd__and2_1
XFILLER_8_280 VGND VGND VPWR VPWR sky130_fd_sc_hd__decap_3
X_2666_ _2657_/B _2661_/X _2663_/Y _2665_/X VGND VGND VPWR VPWR _2672_/B sky130_fd_sc_hd__o211a_1
X_1617_ _1618_/A _1618_/B VGND VGND VPWR VPWR _1787_/A sky130_fd_sc_hd__nor2_1
X_2597_ _2509_/X _2646_/C _2595_/A VGND VGND VPWR VPWR _2597_/Y sky130_fd_sc_hd__a21boi_1
X_1548_ _2003_/A _1509_/B _1506_/X VGND VGND VPWR VPWR _1549_/B sky130_fd_sc_hd__o21bai_1
X_1479_ _1479_/A _1479_/B VGND VGND VPWR VPWR _1481_/B sky130_fd_sc_hd__xor2_1
XFILLER_39_140 VGND VGND VPWR VPWR sky130_fd_sc_hd__decap_3
XTAP_TAPCELL_ROW_37_352 VGND VPWR sky130_fd_sc_hd__tapvpwrvgnd_1
XFILLER_54_187 VGND VGND VPWR VPWR sky130_fd_sc_hd__fill_1
XFILLER_50_360 VGND VGND VPWR VPWR sky130_fd_sc_hd__fill_1
XFILLER_24_56 VGND VGND VPWR VPWR sky130_fd_sc_hd__fill_1
XFILLER_24_78 VGND VGND VPWR VPWR sky130_fd_sc_hd__decap_3
XFILLER_6_206 VGND VGND VPWR VPWR sky130_fd_sc_hd__decap_3
XTAP_TAPCELL_ROW_20_252 VGND VPWR sky130_fd_sc_hd__tapvpwrvgnd_1
XFILLER_40_77 VGND VGND VPWR VPWR sky130_fd_sc_hd__decap_3
XFILLER_40_88 VGND VGND VPWR VPWR sky130_fd_sc_hd__decap_3
XFILLER_6_3 VGND VGND VPWR VPWR sky130_fd_sc_hd__decap_3
XFILLER_49_53 VGND VGND VPWR VPWR sky130_fd_sc_hd__decap_3
XFILLER_49_97 VGND VGND VPWR VPWR sky130_fd_sc_hd__decap_3
XFILLER_49_75 VGND VGND VPWR VPWR sky130_fd_sc_hd__decap_3
XFILLER_1_27 VGND VGND VPWR VPWR sky130_fd_sc_hd__decap_3
XFILLER_45_154 VGND VGND VPWR VPWR sky130_fd_sc_hd__decap_3
XFILLER_60_113 VGND VGND VPWR VPWR sky130_fd_sc_hd__decap_3
XFILLER_45_165 VGND VGND VPWR VPWR sky130_fd_sc_hd__decap_3
XFILLER_33_305 VGND VGND VPWR VPWR sky130_fd_sc_hd__decap_3
XTAP_TAPCELL_ROW_43_388 VGND VPWR sky130_fd_sc_hd__tapvpwrvgnd_1
X_2520_ _2595_/A _2532_/A VGND VGND VPWR VPWR _2521_/B sky130_fd_sc_hd__and2_1
XFILLER_60_6 VGND VGND VPWR VPWR sky130_fd_sc_hd__decap_3
X_2451_ _2700_/B _2700_/C _2700_/A VGND VGND VPWR VPWR _2701_/A sky130_fd_sc_hd__a21oi_1
XFILLER_5_250 VGND VGND VPWR VPWR sky130_fd_sc_hd__decap_3
X_1402_ _1473_/B _1442_/B hold1/A VGND VGND VPWR VPWR _1410_/A sky130_fd_sc_hd__o21bai_2
X_2382_ _2386_/B _2387_/A _2143_/Y _2194_/X VGND VGND VPWR VPWR _2383_/B sky130_fd_sc_hd__a211oi_1
XFILLER_39_3 VGND VGND VPWR VPWR sky130_fd_sc_hd__decap_3
Xinput4 ui_in[1] VGND VGND VPWR VPWR input4/X sky130_fd_sc_hd__buf_1
XFILLER_36_176 VGND VGND VPWR VPWR sky130_fd_sc_hd__decap_3
XFILLER_24_316 VGND VGND VPWR VPWR sky130_fd_sc_hd__fill_1
XTAP_TAPCELL_ROW_34_333 VGND VPWR sky130_fd_sc_hd__tapvpwrvgnd_1
X_2718_ _2632_/C _2706_/X _2632_/B VGND VGND VPWR VPWR _2718_/Y sky130_fd_sc_hd__a21oi_1
XFILLER_10_25 VGND VGND VPWR VPWR sky130_fd_sc_hd__decap_3
X_2649_ _2649_/A _2649_/B VGND VGND VPWR VPWR _2649_/X sky130_fd_sc_hd__xor2_1
XFILLER_59_213 VGND VGND VPWR VPWR sky130_fd_sc_hd__decap_3
XFILLER_59_246 VGND VGND VPWR VPWR sky130_fd_sc_hd__decap_3
XFILLER_19_12 VGND VGND VPWR VPWR sky130_fd_sc_hd__decap_3
XFILLER_59_279 VGND VGND VPWR VPWR sky130_fd_sc_hd__fill_1
XFILLER_27_154 VGND VGND VPWR VPWR sky130_fd_sc_hd__decap_3
XFILLER_15_327 VGND VGND VPWR VPWR sky130_fd_sc_hd__decap_3
XFILLER_35_55 VGND VGND VPWR VPWR sky130_fd_sc_hd__fill_1
XFILLER_27_187 VGND VGND VPWR VPWR sky130_fd_sc_hd__decap_3
XFILLER_42_179 VGND VGND VPWR VPWR sky130_fd_sc_hd__fill_1
XFILLER_42_157 VGND VGND VPWR VPWR sky130_fd_sc_hd__decap_3
XFILLER_51_21 VGND VGND VPWR VPWR sky130_fd_sc_hd__decap_3
XTAP_TAPCELL_ROW_40_369 VGND VPWR sky130_fd_sc_hd__tapvpwrvgnd_1
XFILLER_2_286 VGND VGND VPWR VPWR sky130_fd_sc_hd__decap_3
XFILLER_2_275 VGND VGND VPWR VPWR sky130_fd_sc_hd__fill_2
XFILLER_25_9 VGND VGND VPWR VPWR sky130_fd_sc_hd__fill_1
XFILLER_18_121 VGND VGND VPWR VPWR sky130_fd_sc_hd__decap_3
XFILLER_33_113 VGND VGND VPWR VPWR sky130_fd_sc_hd__decap_3
X_1951_ _2021_/A _1951_/B VGND VGND VPWR VPWR _2026_/B sky130_fd_sc_hd__nand2_1
XTAP_TAPCELL_ROW_31_314 VGND VPWR sky130_fd_sc_hd__tapvpwrvgnd_1
X_1882_ _1947_/A _1881_/C _1881_/A VGND VGND VPWR VPWR _1885_/A sky130_fd_sc_hd__a21boi_1
X_2503_ _2653_/B _2512_/B VGND VGND VPWR VPWR _2503_/Y sky130_fd_sc_hd__nor2_1
X_2434_ _2434_/A _2434_/B _2440_/A VGND VGND VPWR VPWR _2435_/B sky130_fd_sc_hd__and3_1
X_2365_ _2280_/X _2367_/B VGND VGND VPWR VPWR _2394_/B sky130_fd_sc_hd__and2b_1
X_2296_ _2295_/B _2295_/C _2295_/A VGND VGND VPWR VPWR _2297_/C sky130_fd_sc_hd__a21o_1
XFILLER_49_290 VGND VGND VPWR VPWR sky130_fd_sc_hd__decap_3
XFILLER_47_238 VGND VGND VPWR VPWR sky130_fd_sc_hd__decap_3
XFILLER_46_43 VGND VGND VPWR VPWR sky130_fd_sc_hd__decap_3
XFILLER_46_32 VGND VGND VPWR VPWR sky130_fd_sc_hd__decap_3
XFILLER_46_21 VGND VGND VPWR VPWR sky130_fd_sc_hd__decap_3
XFILLER_46_65 VGND VGND VPWR VPWR sky130_fd_sc_hd__fill_1
XFILLER_55_293 VGND VGND VPWR VPWR sky130_fd_sc_hd__decap_3
XFILLER_15_113 VGND VGND VPWR VPWR sky130_fd_sc_hd__decap_3
XTAP_TAPCELL_ROW_53_450 VGND VPWR sky130_fd_sc_hd__tapvpwrvgnd_1
XFILLER_11_330 VGND VGND VPWR VPWR sky130_fd_sc_hd__fill_1
XFILLER_30_149 VGND VGND VPWR VPWR sky130_fd_sc_hd__fill_1
XFILLER_7_15 VGND VGND VPWR VPWR sky130_fd_sc_hd__decap_3
X_2150_ _2283_/A _2150_/B _2150_/C VGND VGND VPWR VPWR _2159_/A sky130_fd_sc_hd__nand3b_1
XFILLER_38_216 VGND VGND VPWR VPWR sky130_fd_sc_hd__decap_3
X_2081_ _1421_/A _1421_/B _2084_/A VGND VGND VPWR VPWR _2149_/B sky130_fd_sc_hd__a21bo_1
XFILLER_38_249 VGND VGND VPWR VPWR sky130_fd_sc_hd__decap_3
XFILLER_21_116 VGND VGND VPWR VPWR sky130_fd_sc_hd__decap_3
X_1934_ _1934_/A _1934_/B VGND VGND VPWR VPWR _1938_/A sky130_fd_sc_hd__nor2_1
X_1865_ _1865_/A _1865_/B VGND VGND VPWR VPWR _1941_/A sky130_fd_sc_hd__or2_1
X_1796_ _2732_/A _2084_/A VGND VGND VPWR VPWR _2283_/B sky130_fd_sc_hd__nand2_1
X_2417_ _2417_/A _2417_/B VGND VGND VPWR VPWR _2653_/B sky130_fd_sc_hd__xor2_4
X_2348_ _2348_/A _2348_/B VGND VGND VPWR VPWR _2350_/A sky130_fd_sc_hd__nor2_1
X_2279_ _2307_/A _2307_/B VGND VGND VPWR VPWR _2279_/X sky130_fd_sc_hd__and2_1
XFILLER_29_249 VGND VGND VPWR VPWR sky130_fd_sc_hd__decap_3
XFILLER_37_293 VGND VGND VPWR VPWR sky130_fd_sc_hd__decap_3
XFILLER_16_35 VGND VGND VPWR VPWR sky130_fd_sc_hd__decap_3
XFILLER_16_24 VGND VGND VPWR VPWR sky130_fd_sc_hd__decap_3
XFILLER_52_230 VGND VGND VPWR VPWR sky130_fd_sc_hd__decap_3
XFILLER_16_68 VGND VGND VPWR VPWR sky130_fd_sc_hd__decap_3
XFILLER_12_127 VGND VGND VPWR VPWR sky130_fd_sc_hd__decap_3
XFILLER_52_274 VGND VGND VPWR VPWR sky130_fd_sc_hd__decap_3
XTAP_TAPCELL_ROW_50_431 VGND VPWR sky130_fd_sc_hd__tapvpwrvgnd_1
XFILLER_32_23 VGND VGND VPWR VPWR sky130_fd_sc_hd__decap_3
XFILLER_20_193 VGND VGND VPWR VPWR sky130_fd_sc_hd__decap_3
XFILLER_4_315 VGND VGND VPWR VPWR sky130_fd_sc_hd__fill_1
XFILLER_4_304 VGND VGND VPWR VPWR sky130_fd_sc_hd__decap_3
XTAP_TAPCELL_ROW_7_175 VGND VPWR sky130_fd_sc_hd__tapvpwrvgnd_1
XFILLER_57_42 VGND VGND VPWR VPWR sky130_fd_sc_hd__decap_3
XFILLER_57_86 VGND VGND VPWR VPWR sky130_fd_sc_hd__decap_3
XFILLER_35_219 VGND VGND VPWR VPWR sky130_fd_sc_hd__decap_3
XFILLER_7_131 VGND VGND VPWR VPWR sky130_fd_sc_hd__decap_3
XFILLER_11_193 VGND VGND VPWR VPWR sky130_fd_sc_hd__decap_3
X_1650_ _1787_/B _1650_/B _1651_/B VGND VGND VPWR VPWR _1650_/X sky130_fd_sc_hd__or3_1
XFILLER_7_153 VGND VGND VPWR VPWR sky130_fd_sc_hd__decap_3
X_1581_ _1628_/A _1606_/A _1581_/S VGND VGND VPWR VPWR _1590_/A sky130_fd_sc_hd__mux2_1
XFILLER_7_197 VGND VGND VPWR VPWR sky130_fd_sc_hd__decap_3
X_2202_ _2159_/A _2152_/C _2152_/A VGND VGND VPWR VPWR _2203_/C sky130_fd_sc_hd__a21o_1
XFILLER_21_3 VGND VGND VPWR VPWR sky130_fd_sc_hd__decap_3
X_2133_ _2131_/A _2131_/Y _2132_/Y _2067_/B VGND VGND VPWR VPWR _2133_/X sky130_fd_sc_hd__o211a_1
XFILLER_26_219 VGND VGND VPWR VPWR sky130_fd_sc_hd__decap_3
X_2064_ _2064_/A _2064_/B VGND VGND VPWR VPWR _2065_/B sky130_fd_sc_hd__xnor2_1
XFILLER_19_293 VGND VGND VPWR VPWR sky130_fd_sc_hd__decap_3
XFILLER_19_260 VGND VGND VPWR VPWR sky130_fd_sc_hd__decap_3
XFILLER_34_263 VGND VGND VPWR VPWR sky130_fd_sc_hd__fill_1
X_1917_ _1441_/A _1441_/B _2219_/B VGND VGND VPWR VPWR _2033_/A sky130_fd_sc_hd__a21o_1
X_1848_ _1924_/A _1924_/B VGND VGND VPWR VPWR _1851_/B sky130_fd_sc_hd__and2b_1
XFILLER_8_80 VGND VGND VPWR VPWR sky130_fd_sc_hd__decap_3
X_1779_ _1779_/A _1784_/A VGND VGND VPWR VPWR _1782_/C sky130_fd_sc_hd__nand2_1
XFILLER_57_311 VGND VGND VPWR VPWR sky130_fd_sc_hd__decap_3
XTAP_TAPCELL_ROW_4_156 VGND VPWR sky130_fd_sc_hd__tapvpwrvgnd_1
XFILLER_57_355 VGND VGND VPWR VPWR sky130_fd_sc_hd__decap_3
XFILLER_17_219 VGND VGND VPWR VPWR sky130_fd_sc_hd__decap_3
XFILLER_27_78 VGND VGND VPWR VPWR sky130_fd_sc_hd__decap_3
XFILLER_25_274 VGND VGND VPWR VPWR sky130_fd_sc_hd__decap_3
XFILLER_25_252 VGND VGND VPWR VPWR sky130_fd_sc_hd__decap_3
XFILLER_25_296 VGND VGND VPWR VPWR sky130_fd_sc_hd__decap_3
XFILLER_43_99 VGND VGND VPWR VPWR sky130_fd_sc_hd__decap_3
XFILLER_43_77 VGND VGND VPWR VPWR sky130_fd_sc_hd__decap_3
XFILLER_4_112 VGND VGND VPWR VPWR sky130_fd_sc_hd__decap_3
XFILLER_4_38 VGND VGND VPWR VPWR sky130_fd_sc_hd__decap_3
XFILLER_4_27 VGND VGND VPWR VPWR sky130_fd_sc_hd__fill_1
XFILLER_0_340 VGND VGND VPWR VPWR sky130_fd_sc_hd__decap_3
XFILLER_48_333 VGND VGND VPWR VPWR sky130_fd_sc_hd__decap_3
XTAP_TAPCELL_ROW_18_236 VGND VPWR sky130_fd_sc_hd__tapvpwrvgnd_1
XFILLER_31_222 VGND VGND VPWR VPWR sky130_fd_sc_hd__fill_2
XFILLER_31_266 VGND VGND VPWR VPWR sky130_fd_sc_hd__decap_3
X_2751_ _2752_/B _2751_/B VGND VGND VPWR VPWR _2771_/D sky130_fd_sc_hd__and2b_1
X_1702_ _1644_/B _1700_/X _1699_/Y _1676_/A VGND VGND VPWR VPWR _1722_/B sky130_fd_sc_hd__o211a_1
X_2682_ _2669_/A _2445_/X _2681_/Y _2669_/Y _2441_/B VGND VGND VPWR VPWR _2682_/Y
+ sky130_fd_sc_hd__o32ai_2
X_1633_ _1633_/A _1633_/B _1633_/C VGND VGND VPWR VPWR _1634_/B sky130_fd_sc_hd__and3_1
X_1564_ _1558_/B _1539_/B _1538_/A VGND VGND VPWR VPWR _1566_/B sky130_fd_sc_hd__a21oi_1
X_1495_ _2774_/Q _1681_/B VGND VGND VPWR VPWR _1495_/Y sky130_fd_sc_hd__nand2_1
XPHY_EDGE_ROW_18_Left_79 VGND VGND VPWR VPWR sky130_fd_sc_hd__decap_3
XFILLER_39_300 VGND VGND VPWR VPWR sky130_fd_sc_hd__decap_3
XFILLER_54_303 VGND VGND VPWR VPWR sky130_fd_sc_hd__decap_3
XFILLER_39_355 VGND VGND VPWR VPWR sky130_fd_sc_hd__decap_3
X_2116_ _2206_/B _2222_/A _2116_/C VGND VGND VPWR VPWR _2171_/B sky130_fd_sc_hd__or3_1
XTAP_TAPCELL_ROW_1_137 VGND VPWR sky130_fd_sc_hd__tapvpwrvgnd_1
XFILLER_54_336 VGND VGND VPWR VPWR sky130_fd_sc_hd__decap_3
X_2047_ _1534_/A _1972_/B _1557_/B _2771_/Q VGND VGND VPWR VPWR _2048_/B sky130_fd_sc_hd__a2bb2o_1
XFILLER_22_200 VGND VGND VPWR VPWR sky130_fd_sc_hd__decap_3
Xfanout15 _2598_/X VGND VGND VPWR VPWR _2660_/A sky130_fd_sc_hd__dlymetal6s2s_1
Xfanout26 _1986_/C VGND VGND VPWR VPWR _2336_/A sky130_fd_sc_hd__buf_2
Xfanout37 _2763_/Q VGND VGND VPWR VPWR _2021_/A sky130_fd_sc_hd__buf_2
XFILLER_22_222 VGND VGND VPWR VPWR sky130_fd_sc_hd__decap_3
Xfanout48 input2/X VGND VGND VPWR VPWR fanout48/X sky130_fd_sc_hd__clkbuf_2
XFILLER_22_277 VGND VGND VPWR VPWR sky130_fd_sc_hd__decap_3
XFILLER_22_244 VGND VGND VPWR VPWR sky130_fd_sc_hd__decap_3
XFILLER_1_126 VGND VGND VPWR VPWR sky130_fd_sc_hd__decap_3
XFILLER_49_119 VGND VGND VPWR VPWR sky130_fd_sc_hd__fill_1
XFILLER_38_44 VGND VGND VPWR VPWR sky130_fd_sc_hd__decap_3
XFILLER_38_88 VGND VGND VPWR VPWR sky130_fd_sc_hd__decap_3
XFILLER_57_163 VGND VGND VPWR VPWR sky130_fd_sc_hd__decap_3
XFILLER_54_32 VGND VGND VPWR VPWR sky130_fd_sc_hd__decap_3
XFILLER_54_21 VGND VGND VPWR VPWR sky130_fd_sc_hd__decap_3
XFILLER_13_222 VGND VGND VPWR VPWR sky130_fd_sc_hd__fill_2
XFILLER_13_233 VGND VGND VPWR VPWR sky130_fd_sc_hd__decap_3
XFILLER_54_76 VGND VGND VPWR VPWR sky130_fd_sc_hd__decap_3
XFILLER_55_9 VGND VGND VPWR VPWR sky130_fd_sc_hd__decap_3
XFILLER_0_181 VGND VGND VPWR VPWR sky130_fd_sc_hd__decap_3
XFILLER_48_141 VGND VGND VPWR VPWR sky130_fd_sc_hd__decap_3
XFILLER_48_163 VGND VGND VPWR VPWR sky130_fd_sc_hd__decap_3
XFILLER_36_303 VGND VGND VPWR VPWR sky130_fd_sc_hd__fill_1
XFILLER_51_317 VGND VGND VPWR VPWR sky130_fd_sc_hd__decap_3
X_2734_ _2735_/A _2735_/B VGND VGND VPWR VPWR _2736_/A sky130_fd_sc_hd__nor2_1
X_2665_ _2719_/B _2665_/B _2665_/C VGND VGND VPWR VPWR _2665_/X sky130_fd_sc_hd__or3_1
X_1616_ _1612_/A _1614_/A _1612_/B _1615_/Y VGND VGND VPWR VPWR _1618_/B sky130_fd_sc_hd__o31a_1
X_2596_ _2643_/C _2646_/C _2595_/Y _2510_/Y VGND VGND VPWR VPWR _2596_/X sky130_fd_sc_hd__a31o_1
X_1547_ _1547_/A _1547_/B VGND VGND VPWR VPWR _1549_/A sky130_fd_sc_hd__nor2_1
X_1478_ _1460_/A _1690_/B _1690_/C VGND VGND VPWR VPWR _1479_/B sky130_fd_sc_hd__a21boi_2
XFILLER_39_152 VGND VGND VPWR VPWR sky130_fd_sc_hd__decap_3
XFILLER_54_100 VGND VGND VPWR VPWR sky130_fd_sc_hd__decap_3
XFILLER_27_347 VGND VGND VPWR VPWR sky130_fd_sc_hd__decap_3
XTAP_TAPCELL_ROW_37_353 VGND VPWR sky130_fd_sc_hd__tapvpwrvgnd_1
XFILLER_42_328 VGND VGND VPWR VPWR sky130_fd_sc_hd__decap_3
XTAP_TAPCELL_ROW_20_253 VGND VPWR sky130_fd_sc_hd__tapvpwrvgnd_1
XFILLER_40_12 VGND VGND VPWR VPWR sky130_fd_sc_hd__decap_3
XFILLER_49_21 VGND VGND VPWR VPWR sky130_fd_sc_hd__decap_3
XFILLER_49_87 VGND VGND VPWR VPWR sky130_fd_sc_hd__fill_1
XFILLER_1_39 VGND VGND VPWR VPWR sky130_fd_sc_hd__decap_3
XFILLER_45_122 VGND VGND VPWR VPWR sky130_fd_sc_hd__decap_3
XFILLER_18_347 VGND VGND VPWR VPWR sky130_fd_sc_hd__decap_3
XFILLER_60_103 VGND VGND VPWR VPWR sky130_fd_sc_hd__decap_3
XFILLER_33_317 VGND VGND VPWR VPWR sky130_fd_sc_hd__decap_3
XFILLER_60_125 VGND VGND VPWR VPWR sky130_fd_sc_hd__decap_3
XFILLER_60_169 VGND VGND VPWR VPWR sky130_fd_sc_hd__decap_3
XFILLER_60_147 VGND VGND VPWR VPWR sky130_fd_sc_hd__decap_3
XTAP_TAPCELL_ROW_43_389 VGND VPWR sky130_fd_sc_hd__tapvpwrvgnd_1
X_2450_ _2694_/A _2694_/B _2694_/C VGND VGND VPWR VPWR _2700_/C sky130_fd_sc_hd__a21o_1
XFILLER_5_273 VGND VGND VPWR VPWR sky130_fd_sc_hd__decap_3
XFILLER_53_6 VGND VGND VPWR VPWR sky130_fd_sc_hd__decap_3
X_1401_ _2767_/Q _1438_/B _1416_/D _1414_/A VGND VGND VPWR VPWR _1411_/A sky130_fd_sc_hd__o31a_2
XFILLER_5_284 VGND VGND VPWR VPWR sky130_fd_sc_hd__decap_3
X_2381_ _2620_/A _2473_/A VGND VGND VPWR VPWR _2453_/A sky130_fd_sc_hd__xnor2_1
Xinput5 ui_in[2] VGND VGND VPWR VPWR input5/X sky130_fd_sc_hd__clkbuf_1
XFILLER_36_144 VGND VGND VPWR VPWR sky130_fd_sc_hd__decap_3
XFILLER_36_133 VGND VGND VPWR VPWR sky130_fd_sc_hd__decap_3
XFILLER_51_103 VGND VGND VPWR VPWR sky130_fd_sc_hd__decap_3
XFILLER_51_125 VGND VGND VPWR VPWR sky130_fd_sc_hd__decap_3
XTAP_TAPCELL_ROW_34_334 VGND VPWR sky130_fd_sc_hd__tapvpwrvgnd_1
XFILLER_51_169 VGND VGND VPWR VPWR sky130_fd_sc_hd__decap_3
X_2717_ input6/X _2717_/B VGND VGND VPWR VPWR uo_out[6] sky130_fd_sc_hd__xor2_4
XFILLER_10_59 VGND VGND VPWR VPWR sky130_fd_sc_hd__fill_1
X_2648_ _2669_/B _2642_/B _2646_/X _2647_/Y VGND VGND VPWR VPWR _2648_/X sky130_fd_sc_hd__o31a_1
X_2579_ _2559_/B _2623_/B _2557_/X VGND VGND VPWR VPWR _2626_/A sky130_fd_sc_hd__a21o_1
XFILLER_59_225 VGND VGND VPWR VPWR sky130_fd_sc_hd__decap_3
XFILLER_59_258 VGND VGND VPWR VPWR sky130_fd_sc_hd__decap_3
XFILLER_27_111 VGND VGND VPWR VPWR sky130_fd_sc_hd__fill_1
XFILLER_35_12 VGND VGND VPWR VPWR sky130_fd_sc_hd__decap_3
XFILLER_15_306 VGND VGND VPWR VPWR sky130_fd_sc_hd__decap_3
XFILLER_35_67 VGND VGND VPWR VPWR sky130_fd_sc_hd__fill_2
XFILLER_35_89 VGND VGND VPWR VPWR sky130_fd_sc_hd__decap_3
XFILLER_30_309 VGND VGND VPWR VPWR sky130_fd_sc_hd__decap_3
XFILLER_50_191 VGND VGND VPWR VPWR sky130_fd_sc_hd__decap_3
XFILLER_51_66 VGND VGND VPWR VPWR sky130_fd_sc_hd__decap_3
XFILLER_51_55 VGND VGND VPWR VPWR sky130_fd_sc_hd__fill_1
XFILLER_2_210 VGND VGND VPWR VPWR sky130_fd_sc_hd__decap_3
XFILLER_18_9 VGND VGND VPWR VPWR sky130_fd_sc_hd__decap_3
XFILLER_58_280 VGND VGND VPWR VPWR sky130_fd_sc_hd__decap_3
XFILLER_18_155 VGND VGND VPWR VPWR sky130_fd_sc_hd__fill_2
XFILLER_33_169 VGND VGND VPWR VPWR sky130_fd_sc_hd__decap_3
XFILLER_21_309 VGND VGND VPWR VPWR sky130_fd_sc_hd__decap_3
X_1950_ _2199_/B _2026_/A VGND VGND VPWR VPWR _2024_/A sky130_fd_sc_hd__xnor2_1
XTAP_TAPCELL_ROW_31_315 VGND VPWR sky130_fd_sc_hd__tapvpwrvgnd_1
X_1881_ _1881_/A _1947_/A _1881_/C VGND VGND VPWR VPWR _1955_/A sky130_fd_sc_hd__and3_1
XFILLER_41_191 VGND VGND VPWR VPWR sky130_fd_sc_hd__decap_3
X_2502_ _2512_/B _2663_/A VGND VGND VPWR VPWR _2502_/X sky130_fd_sc_hd__and2b_1
XFILLER_51_3 VGND VGND VPWR VPWR sky130_fd_sc_hd__decap_3
X_2433_ _2776_/Q _2448_/B VGND VGND VPWR VPWR _2700_/B sky130_fd_sc_hd__nand2_1
X_2364_ _2398_/A _2398_/B _2308_/X VGND VGND VPWR VPWR _2394_/A sky130_fd_sc_hd__a21o_1
X_2295_ _2295_/A _2295_/B _2295_/C VGND VGND VPWR VPWR _2297_/B sky130_fd_sc_hd__nand3_1
XFILLER_56_228 VGND VGND VPWR VPWR sky130_fd_sc_hd__decap_3
XFILLER_56_206 VGND VGND VPWR VPWR sky130_fd_sc_hd__decap_3
XFILLER_2_93 VGND VGND VPWR VPWR sky130_fd_sc_hd__fill_1
XFILLER_12_309 VGND VGND VPWR VPWR sky130_fd_sc_hd__fill_1
XFILLER_24_136 VGND VGND VPWR VPWR sky130_fd_sc_hd__decap_3
XFILLER_32_191 VGND VGND VPWR VPWR sky130_fd_sc_hd__decap_3
XFILLER_32_180 VGND VGND VPWR VPWR sky130_fd_sc_hd__decap_3
XFILLER_20_331 VGND VGND VPWR VPWR sky130_fd_sc_hd__decap_3
XFILLER_47_217 VGND VGND VPWR VPWR sky130_fd_sc_hd__decap_3
XFILLER_47_206 VGND VGND VPWR VPWR sky130_fd_sc_hd__decap_3
XPHY_EDGE_ROW_6_Left_67 VGND VGND VPWR VPWR sky130_fd_sc_hd__decap_3
XFILLER_55_261 VGND VGND VPWR VPWR sky130_fd_sc_hd__decap_3
XFILLER_46_88 VGND VGND VPWR VPWR sky130_fd_sc_hd__decap_3
XFILLER_15_103 VGND VGND VPWR VPWR sky130_fd_sc_hd__decap_3
XFILLER_15_158 VGND VGND VPWR VPWR sky130_fd_sc_hd__fill_1
XTAP_TAPCELL_ROW_53_451 VGND VPWR sky130_fd_sc_hd__tapvpwrvgnd_1
XFILLER_11_320 VGND VGND VPWR VPWR sky130_fd_sc_hd__fill_2
XFILLER_7_324 VGND VGND VPWR VPWR sky130_fd_sc_hd__decap_3
XFILLER_7_313 VGND VGND VPWR VPWR sky130_fd_sc_hd__decap_3
XFILLER_7_27 VGND VGND VPWR VPWR sky130_fd_sc_hd__decap_3
XFILLER_38_228 VGND VGND VPWR VPWR sky130_fd_sc_hd__decap_3
X_2080_ _2080_/A _2080_/B VGND VGND VPWR VPWR _2143_/A sky130_fd_sc_hd__xnor2_1
XFILLER_53_209 VGND VGND VPWR VPWR sky130_fd_sc_hd__decap_3
X_1933_ _1934_/A _1933_/B _1933_/C VGND VGND VPWR VPWR _1934_/B sky130_fd_sc_hd__nor3_1
X_1864_ _1866_/B _1866_/A VGND VGND VPWR VPWR _1943_/A sky130_fd_sc_hd__and2b_1
X_1795_ _2249_/B _1886_/A VGND VGND VPWR VPWR _1878_/C sky130_fd_sc_hd__nor2_1
X_2416_ _2459_/A _2498_/A VGND VGND VPWR VPWR _2460_/A sky130_fd_sc_hd__nand2_1
X_2347_ _2347_/A _2347_/B VGND VGND VPWR VPWR _2348_/B sky130_fd_sc_hd__nor2_1
XFILLER_29_206 VGND VGND VPWR VPWR sky130_fd_sc_hd__decap_3
X_2278_ _2278_/A _2278_/B VGND VGND VPWR VPWR _2307_/B sky130_fd_sc_hd__xor2_1
XFILLER_29_228 VGND VGND VPWR VPWR sky130_fd_sc_hd__decap_3
XFILLER_52_253 VGND VGND VPWR VPWR sky130_fd_sc_hd__decap_3
XFILLER_16_47 VGND VGND VPWR VPWR sky130_fd_sc_hd__decap_3
XFILLER_12_106 VGND VGND VPWR VPWR sky130_fd_sc_hd__fill_1
XFILLER_52_286 VGND VGND VPWR VPWR sky130_fd_sc_hd__decap_3
XTAP_TAPCELL_ROW_50_432 VGND VPWR sky130_fd_sc_hd__tapvpwrvgnd_1
XFILLER_20_161 VGND VGND VPWR VPWR sky130_fd_sc_hd__decap_3
XFILLER_57_21 VGND VGND VPWR VPWR sky130_fd_sc_hd__decap_3
XFILLER_57_54 VGND VGND VPWR VPWR sky130_fd_sc_hd__fill_2
XFILLER_57_98 VGND VGND VPWR VPWR sky130_fd_sc_hd__decap_3
XFILLER_43_220 VGND VGND VPWR VPWR sky130_fd_sc_hd__decap_3
XFILLER_28_294 VGND VGND VPWR VPWR sky130_fd_sc_hd__fill_1
XFILLER_11_150 VGND VGND VPWR VPWR sky130_fd_sc_hd__decap_3
XFILLER_11_172 VGND VGND VPWR VPWR sky130_fd_sc_hd__decap_3
XFILLER_7_165 VGND VGND VPWR VPWR sky130_fd_sc_hd__decap_3
XFILLER_7_143 VGND VGND VPWR VPWR sky130_fd_sc_hd__fill_1
X_1580_ _1752_/A _1580_/B VGND VGND VPWR VPWR _1771_/A sky130_fd_sc_hd__or2_1
X_2201_ _2735_/A _2201_/B _2250_/B VGND VGND VPWR VPWR _2203_/B sky130_fd_sc_hd__and3_1
X_2132_ _2066_/A _2066_/B _2066_/C VGND VGND VPWR VPWR _2132_/Y sky130_fd_sc_hd__o21ai_1
XFILLER_14_3 VGND VGND VPWR VPWR sky130_fd_sc_hd__fill_2
XFILLER_19_250 VGND VGND VPWR VPWR sky130_fd_sc_hd__fill_1
X_2063_ _2064_/B _2064_/A VGND VGND VPWR VPWR _2063_/X sky130_fd_sc_hd__and2b_1
XFILLER_34_231 VGND VGND VPWR VPWR sky130_fd_sc_hd__decap_3
X_1916_ _1441_/A _1441_/B _2219_/B VGND VGND VPWR VPWR _1916_/Y sky130_fd_sc_hd__a21oi_1
X_1847_ _1847_/A _1847_/B VGND VGND VPWR VPWR _1924_/B sky130_fd_sc_hd__xor2_1
X_1778_ _1783_/A _1783_/B VGND VGND VPWR VPWR _1784_/A sky130_fd_sc_hd__nand2_1
XTAP_TAPCELL_ROW_4_157 VGND VPWR sky130_fd_sc_hd__tapvpwrvgnd_1
XFILLER_57_323 VGND VGND VPWR VPWR sky130_fd_sc_hd__decap_3
XFILLER_27_13 VGND VGND VPWR VPWR sky130_fd_sc_hd__decap_3
XFILLER_27_57 VGND VGND VPWR VPWR sky130_fd_sc_hd__decap_3
XFILLER_25_231 VGND VGND VPWR VPWR sky130_fd_sc_hd__decap_3
XFILLER_43_12 VGND VGND VPWR VPWR sky130_fd_sc_hd__decap_3
XFILLER_43_34 VGND VGND VPWR VPWR sky130_fd_sc_hd__decap_3
XFILLER_40_278 VGND VGND VPWR VPWR sky130_fd_sc_hd__decap_3
XFILLER_4_124 VGND VGND VPWR VPWR sky130_fd_sc_hd__decap_3
XFILLER_0_330 VGND VGND VPWR VPWR sky130_fd_sc_hd__decap_3
XFILLER_0_352 VGND VGND VPWR VPWR sky130_fd_sc_hd__decap_3
XFILLER_48_312 VGND VGND VPWR VPWR sky130_fd_sc_hd__decap_3
XFILLER_48_345 VGND VGND VPWR VPWR sky130_fd_sc_hd__decap_3
XTAP_TAPCELL_ROW_18_237 VGND VPWR sky130_fd_sc_hd__tapvpwrvgnd_1
XFILLER_16_242 VGND VGND VPWR VPWR sky130_fd_sc_hd__fill_1
XPHY_EDGE_ROW_9_Left_70 VGND VGND VPWR VPWR sky130_fd_sc_hd__decap_3
XFILLER_31_201 VGND VGND VPWR VPWR sky130_fd_sc_hd__decap_3
XFILLER_17_90 VGND VGND VPWR VPWR sky130_fd_sc_hd__decap_3
X_2750_ _2206_/A _2749_/B _1898_/A VGND VGND VPWR VPWR _2751_/B sky130_fd_sc_hd__o21ai_1
XFILLER_31_289 VGND VGND VPWR VPWR sky130_fd_sc_hd__fill_2
XFILLER_31_278 VGND VGND VPWR VPWR sky130_fd_sc_hd__fill_2
X_1701_ _1676_/A _1699_/Y _1700_/X _1644_/B VGND VGND VPWR VPWR _1727_/A sky130_fd_sc_hd__a211oi_2
X_2681_ _2754_/A _2675_/S _2445_/B VGND VGND VPWR VPWR _2681_/Y sky130_fd_sc_hd__a21oi_1
X_1632_ _1633_/A _1633_/B _1633_/C VGND VGND VPWR VPWR _1640_/A sky130_fd_sc_hd__a21oi_1
X_1563_ _1754_/A _1563_/B VGND VGND VPWR VPWR _1565_/B sky130_fd_sc_hd__xor2_1
X_1494_ _2754_/A _1494_/B VGND VGND VPWR VPWR _2219_/B sky130_fd_sc_hd__xnor2_4
XFILLER_39_312 VGND VGND VPWR VPWR sky130_fd_sc_hd__decap_3
X_2115_ _1444_/Y _1451_/X _1450_/X _2770_/Q VGND VGND VPWR VPWR _2115_/X sky130_fd_sc_hd__o211a_1
XTAP_TAPCELL_ROW_1_138 VGND VPWR sky130_fd_sc_hd__tapvpwrvgnd_1
XFILLER_54_315 VGND VGND VPWR VPWR sky130_fd_sc_hd__decap_3
X_2046_ _2206_/B _2356_/A VGND VGND VPWR VPWR _2100_/A sky130_fd_sc_hd__nor2_1
XFILLER_54_348 VGND VGND VPWR VPWR sky130_fd_sc_hd__decap_3
Xfanout16 _2468_/X VGND VGND VPWR VPWR _2696_/A sky130_fd_sc_hd__clkbuf_4
Xfanout27 _1820_/B VGND VGND VPWR VPWR _2057_/A sky130_fd_sc_hd__clkbuf_4
Xfanout38 _2762_/Q VGND VGND VPWR VPWR _2732_/A sky130_fd_sc_hd__buf_2
XFILLER_13_15 VGND VGND VPWR VPWR sky130_fd_sc_hd__decap_3
XFILLER_22_256 VGND VGND VPWR VPWR sky130_fd_sc_hd__decap_3
XFILLER_22_289 VGND VGND VPWR VPWR sky130_fd_sc_hd__decap_3
XFILLER_49_109 VGND VGND VPWR VPWR sky130_fd_sc_hd__decap_3
XFILLER_38_12 VGND VGND VPWR VPWR sky130_fd_sc_hd__decap_3
XFILLER_57_175 VGND VGND VPWR VPWR sky130_fd_sc_hd__decap_3
XFILLER_57_197 VGND VGND VPWR VPWR sky130_fd_sc_hd__decap_3
XFILLER_45_348 VGND VGND VPWR VPWR sky130_fd_sc_hd__decap_3
XFILLER_60_318 VGND VGND VPWR VPWR sky130_fd_sc_hd__decap_3
XFILLER_54_44 VGND VGND VPWR VPWR sky130_fd_sc_hd__decap_3
XFILLER_13_212 VGND VGND VPWR VPWR sky130_fd_sc_hd__decap_3
XTAP_TAPCELL_ROW_15_218 VGND VPWR sky130_fd_sc_hd__tapvpwrvgnd_1
XFILLER_54_88 VGND VGND VPWR VPWR sky130_fd_sc_hd__decap_3
XFILLER_13_267 VGND VGND VPWR VPWR sky130_fd_sc_hd__decap_3
XFILLER_9_216 VGND VGND VPWR VPWR sky130_fd_sc_hd__decap_3
XPHY_EDGE_ROW_35_Left_96 VGND VGND VPWR VPWR sky130_fd_sc_hd__decap_3
XFILLER_9_249 VGND VGND VPWR VPWR sky130_fd_sc_hd__decap_3
XFILLER_9_238 VGND VGND VPWR VPWR sky130_fd_sc_hd__decap_3
XFILLER_48_9 VGND VGND VPWR VPWR sky130_fd_sc_hd__decap_3
XFILLER_0_193 VGND VGND VPWR VPWR sky130_fd_sc_hd__decap_3
XFILLER_48_175 VGND VGND VPWR VPWR sky130_fd_sc_hd__decap_3
XFILLER_36_315 VGND VGND VPWR VPWR sky130_fd_sc_hd__decap_3
XFILLER_48_197 VGND VGND VPWR VPWR sky130_fd_sc_hd__decap_3
XFILLER_36_359 VGND VGND VPWR VPWR sky130_fd_sc_hd__fill_2
XFILLER_36_337 VGND VGND VPWR VPWR sky130_fd_sc_hd__decap_3
XFILLER_51_329 VGND VGND VPWR VPWR sky130_fd_sc_hd__decap_3
X_2733_ _2733_/A _2735_/B VGND VGND VPWR VPWR _2762_/D sky130_fd_sc_hd__nor2_1
XFILLER_8_271 VGND VGND VPWR VPWR sky130_fd_sc_hd__decap_3
X_2664_ _2419_/Y _2502_/X _2663_/A _2426_/A VGND VGND VPWR VPWR _2665_/C sky130_fd_sc_hd__o2bb2a_1
X_1615_ _1645_/A _1645_/B VGND VGND VPWR VPWR _1615_/Y sky130_fd_sc_hd__nand2b_1
X_2595_ _2595_/A _2595_/B VGND VGND VPWR VPWR _2595_/Y sky130_fd_sc_hd__nand2_1
X_1546_ _1774_/A _1546_/B _1546_/C VGND VGND VPWR VPWR _1547_/B sky130_fd_sc_hd__and3_1
XFILLER_5_60 VGND VGND VPWR VPWR sky130_fd_sc_hd__decap_3
X_1477_ _1820_/B _1972_/A _2217_/B VGND VGND VPWR VPWR _1690_/C sky130_fd_sc_hd__or3_1
XFILLER_39_131 VGND VGND VPWR VPWR sky130_fd_sc_hd__decap_3
XFILLER_39_175 VGND VGND VPWR VPWR sky130_fd_sc_hd__fill_1
XFILLER_39_164 VGND VGND VPWR VPWR sky130_fd_sc_hd__decap_3
XFILLER_27_315 VGND VGND VPWR VPWR sky130_fd_sc_hd__decap_3
XFILLER_54_123 VGND VGND VPWR VPWR sky130_fd_sc_hd__decap_3
XFILLER_54_112 VGND VGND VPWR VPWR sky130_fd_sc_hd__fill_2
XFILLER_39_197 VGND VGND VPWR VPWR sky130_fd_sc_hd__decap_3
XTAP_TAPCELL_ROW_37_354 VGND VPWR sky130_fd_sc_hd__tapvpwrvgnd_1
XPHY_EDGE_ROW_59_Left_120 VGND VGND VPWR VPWR sky130_fd_sc_hd__decap_3
XFILLER_54_178 VGND VGND VPWR VPWR sky130_fd_sc_hd__decap_3
XFILLER_54_167 VGND VGND VPWR VPWR sky130_fd_sc_hd__fill_1
X_2029_ _2029_/A _2029_/B VGND VGND VPWR VPWR _2029_/X sky130_fd_sc_hd__or2_1
XFILLER_50_351 VGND VGND VPWR VPWR sky130_fd_sc_hd__decap_3
XFILLER_24_69 VGND VGND VPWR VPWR sky130_fd_sc_hd__decap_3
XFILLER_10_259 VGND VGND VPWR VPWR sky130_fd_sc_hd__decap_3
XFILLER_40_24 VGND VGND VPWR VPWR sky130_fd_sc_hd__decap_3
XFILLER_40_46 VGND VGND VPWR VPWR sky130_fd_sc_hd__decap_3
XFILLER_49_33 VGND VGND VPWR VPWR sky130_fd_sc_hd__fill_2
XFILLER_49_66 VGND VGND VPWR VPWR sky130_fd_sc_hd__fill_1
XFILLER_1_18 VGND VGND VPWR VPWR sky130_fd_sc_hd__decap_3
XFILLER_18_326 VGND VGND VPWR VPWR sky130_fd_sc_hd__fill_2
XFILLER_45_145 VGND VGND VPWR VPWR sky130_fd_sc_hd__decap_3
XFILLER_45_134 VGND VGND VPWR VPWR sky130_fd_sc_hd__fill_2
XFILLER_18_359 VGND VGND VPWR VPWR sky130_fd_sc_hd__fill_2
XFILLER_45_178 VGND VGND VPWR VPWR sky130_fd_sc_hd__fill_2
XFILLER_60_137 VGND VGND VPWR VPWR sky130_fd_sc_hd__decap_3
XFILLER_33_329 VGND VGND VPWR VPWR sky130_fd_sc_hd__decap_3
XFILLER_60_159 VGND VGND VPWR VPWR sky130_fd_sc_hd__decap_3
X_1400_ _2768_/Q _1442_/B _1473_/B VGND VGND VPWR VPWR _1414_/A sky130_fd_sc_hd__or3b_1
XFILLER_46_6 VGND VGND VPWR VPWR sky130_fd_sc_hd__decap_3
X_2380_ _2380_/A _2380_/B VGND VGND VPWR VPWR _2473_/A sky130_fd_sc_hd__xnor2_2
Xinput6 ui_in[3] VGND VGND VPWR VPWR input6/X sky130_fd_sc_hd__buf_12
XFILLER_36_112 VGND VGND VPWR VPWR sky130_fd_sc_hd__decap_3
XFILLER_36_156 VGND VGND VPWR VPWR sky130_fd_sc_hd__decap_3
XFILLER_24_307 VGND VGND VPWR VPWR sky130_fd_sc_hd__fill_1
XTAP_TAPCELL_ROW_34_335 VGND VPWR sky130_fd_sc_hd__tapvpwrvgnd_1
X_2716_ _2672_/X _2713_/X _2715_/X _2696_/A VGND VGND VPWR VPWR _2717_/B sky130_fd_sc_hd__o31a_2
XFILLER_10_16 VGND VGND VPWR VPWR sky130_fd_sc_hd__decap_3
X_2647_ _2656_/B _2669_/B _2468_/A VGND VGND VPWR VPWR _2647_/Y sky130_fd_sc_hd__a21oi_1
XFILLER_10_38 VGND VGND VPWR VPWR sky130_fd_sc_hd__decap_3
X_2578_ _2605_/A _2605_/B _2563_/X VGND VGND VPWR VPWR _2623_/B sky130_fd_sc_hd__a21o_1
X_1529_ _1628_/A _1601_/B VGND VGND VPWR VPWR _1531_/C sky130_fd_sc_hd__nor2_1
XFILLER_59_237 VGND VGND VPWR VPWR sky130_fd_sc_hd__decap_3
XFILLER_35_24 VGND VGND VPWR VPWR sky130_fd_sc_hd__fill_1
XFILLER_27_167 VGND VGND VPWR VPWR sky130_fd_sc_hd__fill_1
XFILLER_42_126 VGND VGND VPWR VPWR sky130_fd_sc_hd__decap_3
XFILLER_35_57 VGND VGND VPWR VPWR sky130_fd_sc_hd__fill_2
XFILLER_35_46 VGND VGND VPWR VPWR sky130_fd_sc_hd__decap_3
XFILLER_27_178 VGND VGND VPWR VPWR sky130_fd_sc_hd__decap_3
XFILLER_15_318 VGND VGND VPWR VPWR sky130_fd_sc_hd__decap_3
XFILLER_51_12 VGND VGND VPWR VPWR sky130_fd_sc_hd__decap_3
XPHY_EDGE_ROW_14_Right_14 VGND VGND VPWR VPWR sky130_fd_sc_hd__decap_3
XFILLER_51_78 VGND VGND VPWR VPWR sky130_fd_sc_hd__decap_3
XFILLER_51_89 VGND VGND VPWR VPWR sky130_fd_sc_hd__decap_3
XFILLER_2_222 VGND VGND VPWR VPWR sky130_fd_sc_hd__fill_1
XPHY_EDGE_ROW_23_Right_23 VGND VGND VPWR VPWR sky130_fd_sc_hd__decap_3
XFILLER_2_266 VGND VGND VPWR VPWR sky130_fd_sc_hd__decap_3
XTAP_TAPCELL_ROW_48_416 VGND VPWR sky130_fd_sc_hd__tapvpwrvgnd_1
XFILLER_58_292 VGND VGND VPWR VPWR sky130_fd_sc_hd__decap_3
XFILLER_33_104 VGND VGND VPWR VPWR sky130_fd_sc_hd__decap_3
XPHY_EDGE_ROW_32_Right_32 VGND VGND VPWR VPWR sky130_fd_sc_hd__decap_3
XFILLER_33_148 VGND VGND VPWR VPWR sky130_fd_sc_hd__decap_3
XFILLER_33_137 VGND VGND VPWR VPWR sky130_fd_sc_hd__decap_3
XTAP_TAPCELL_ROW_31_316 VGND VPWR sky130_fd_sc_hd__tapvpwrvgnd_1
X_1880_ _1799_/X _1877_/Y _1876_/Y VGND VGND VPWR VPWR _1881_/C sky130_fd_sc_hd__a21o_1
X_2501_ _2512_/A _2663_/A _2512_/B VGND VGND VPWR VPWR _2501_/X sky130_fd_sc_hd__a21bo_1
X_2432_ _2432_/A _2432_/B VGND VGND VPWR VPWR _2448_/B sky130_fd_sc_hd__and2_1
XPHY_EDGE_ROW_41_Right_41 VGND VGND VPWR VPWR sky130_fd_sc_hd__decap_3
XFILLER_44_3 VGND VGND VPWR VPWR sky130_fd_sc_hd__decap_3
X_2363_ _2363_/A _2363_/B VGND VGND VPWR VPWR _2398_/B sky130_fd_sc_hd__xnor2_4
XPHY_EDGE_ROW_22_Left_83 VGND VGND VPWR VPWR sky130_fd_sc_hd__decap_3
X_2294_ _2293_/A _2293_/C _2293_/B VGND VGND VPWR VPWR _2295_/C sky130_fd_sc_hd__a21o_1
XFILLER_2_50 VGND VGND VPWR VPWR sky130_fd_sc_hd__decap_3
XFILLER_49_281 VGND VGND VPWR VPWR sky130_fd_sc_hd__decap_3
XPHY_EDGE_ROW_50_Right_50 VGND VGND VPWR VPWR sky130_fd_sc_hd__decap_3
XFILLER_24_115 VGND VGND VPWR VPWR sky130_fd_sc_hd__decap_3
XFILLER_46_12 VGND VGND VPWR VPWR sky130_fd_sc_hd__decap_3
XFILLER_46_56 VGND VGND VPWR VPWR sky130_fd_sc_hd__decap_3
XFILLER_55_284 VGND VGND VPWR VPWR sky130_fd_sc_hd__decap_3
XFILLER_55_273 VGND VGND VPWR VPWR sky130_fd_sc_hd__decap_3
XFILLER_30_107 VGND VGND VPWR VPWR sky130_fd_sc_hd__decap_3
XFILLER_11_354 VGND VGND VPWR VPWR sky130_fd_sc_hd__decap_3
XFILLER_7_39 VGND VGND VPWR VPWR sky130_fd_sc_hd__decap_3
XFILLER_7_358 VGND VGND VPWR VPWR sky130_fd_sc_hd__decap_3
XFILLER_30_9 VGND VGND VPWR VPWR sky130_fd_sc_hd__decap_3
XFILLER_38_207 VGND VGND VPWR VPWR sky130_fd_sc_hd__decap_3
XFILLER_46_240 VGND VGND VPWR VPWR sky130_fd_sc_hd__decap_3
XFILLER_46_273 VGND VGND VPWR VPWR sky130_fd_sc_hd__decap_3
XFILLER_14_192 VGND VGND VPWR VPWR sky130_fd_sc_hd__decap_3
X_1932_ _1932_/A _1932_/B VGND VGND VPWR VPWR _1933_/C sky130_fd_sc_hd__xnor2_1
X_1863_ _1863_/A _1863_/B VGND VGND VPWR VPWR _1866_/B sky130_fd_sc_hd__or2_1
X_1794_ _1793_/X _1794_/B _1871_/A VGND VGND VPWR VPWR _2506_/A sky130_fd_sc_hd__and3b_2
X_2415_ _2371_/X _2372_/X _2414_/X VGND VGND VPWR VPWR _2498_/A sky130_fd_sc_hd__a21bo_2
X_2346_ _2346_/A _2348_/A VGND VGND VPWR VPWR _2346_/X sky130_fd_sc_hd__xor2_1
X_2277_ _2278_/A _2278_/B VGND VGND VPWR VPWR _2277_/Y sky130_fd_sc_hd__nor2_1
XFILLER_52_210 VGND VGND VPWR VPWR sky130_fd_sc_hd__decap_3
XFILLER_37_284 VGND VGND VPWR VPWR sky130_fd_sc_hd__fill_2
XFILLER_37_273 VGND VGND VPWR VPWR sky130_fd_sc_hd__decap_3
XFILLER_52_243 VGND VGND VPWR VPWR sky130_fd_sc_hd__decap_3
XFILLER_52_221 VGND VGND VPWR VPWR sky130_fd_sc_hd__decap_3
XFILLER_16_59 VGND VGND VPWR VPWR sky130_fd_sc_hd__decap_3
XFILLER_52_265 VGND VGND VPWR VPWR sky130_fd_sc_hd__decap_3
XTAP_TAPCELL_ROW_50_433 VGND VPWR sky130_fd_sc_hd__tapvpwrvgnd_1
XFILLER_52_298 VGND VGND VPWR VPWR sky130_fd_sc_hd__decap_3
XFILLER_32_47 VGND VGND VPWR VPWR sky130_fd_sc_hd__fill_1
XFILLER_20_173 VGND VGND VPWR VPWR sky130_fd_sc_hd__decap_3
XFILLER_57_33 VGND VGND VPWR VPWR sky130_fd_sc_hd__decap_3
XFILLER_57_77 VGND VGND VPWR VPWR sky130_fd_sc_hd__decap_3
XFILLER_43_287 VGND VGND VPWR VPWR sky130_fd_sc_hd__fill_2
XFILLER_7_122 VGND VGND VPWR VPWR sky130_fd_sc_hd__decap_3
XFILLER_7_111 VGND VGND VPWR VPWR sky130_fd_sc_hd__fill_1
XFILLER_11_184 VGND VGND VPWR VPWR sky130_fd_sc_hd__decap_3
X_2200_ _2253_/A _2199_/Y _2286_/B _2149_/B VGND VGND VPWR VPWR _2250_/B sky130_fd_sc_hd__o2bb2a_1
X_2131_ _2131_/A _2131_/B _2131_/C VGND VGND VPWR VPWR _2131_/Y sky130_fd_sc_hd__nor3_1
X_2062_ _2062_/A _2062_/B VGND VGND VPWR VPWR _2064_/B sky130_fd_sc_hd__xor2_1
XFILLER_34_243 VGND VGND VPWR VPWR sky130_fd_sc_hd__decap_3
XFILLER_34_210 VGND VGND VPWR VPWR sky130_fd_sc_hd__decap_3
X_1915_ _1915_/A _1915_/B _1915_/C VGND VGND VPWR VPWR _1933_/B sky130_fd_sc_hd__nor3_1
X_1846_ _1995_/A _1995_/B _1841_/A VGND VGND VPWR VPWR _1924_/A sky130_fd_sc_hd__a21oi_1
XFILLER_8_71 VGND VGND VPWR VPWR sky130_fd_sc_hd__decap_3
X_1777_ _1779_/A _1777_/B VGND VGND VPWR VPWR _1783_/B sky130_fd_sc_hd__and2_1
XPHY_EDGE_ROW_4_Right_4 VGND VGND VPWR VPWR sky130_fd_sc_hd__decap_3
XFILLER_57_302 VGND VGND VPWR VPWR sky130_fd_sc_hd__decap_3
X_2329_ _2330_/B _2330_/A VGND VGND VPWR VPWR _2329_/X sky130_fd_sc_hd__and2b_1
XFILLER_57_335 VGND VGND VPWR VPWR sky130_fd_sc_hd__fill_1
XFILLER_57_346 VGND VGND VPWR VPWR sky130_fd_sc_hd__decap_3
XFILLER_27_25 VGND VGND VPWR VPWR sky130_fd_sc_hd__fill_2
XPHY_EDGE_ROW_40_Left_101 VGND VGND VPWR VPWR sky130_fd_sc_hd__decap_3
XFILLER_27_69 VGND VGND VPWR VPWR sky130_fd_sc_hd__decap_3
XFILLER_25_210 VGND VGND VPWR VPWR sky130_fd_sc_hd__decap_3
XFILLER_25_243 VGND VGND VPWR VPWR sky130_fd_sc_hd__decap_3
XFILLER_43_46 VGND VGND VPWR VPWR sky130_fd_sc_hd__decap_3
XFILLER_43_24 VGND VGND VPWR VPWR sky130_fd_sc_hd__decap_3
XFILLER_40_224 VGND VGND VPWR VPWR sky130_fd_sc_hd__decap_3
XFILLER_43_68 VGND VGND VPWR VPWR sky130_fd_sc_hd__fill_2
XFILLER_4_147 VGND VGND VPWR VPWR sky130_fd_sc_hd__decap_3
XFILLER_4_136 VGND VGND VPWR VPWR sky130_fd_sc_hd__decap_3
XFILLER_4_29 VGND VGND VPWR VPWR sky130_fd_sc_hd__decap_3
XFILLER_4_18 VGND VGND VPWR VPWR sky130_fd_sc_hd__decap_3
XFILLER_48_302 VGND VGND VPWR VPWR sky130_fd_sc_hd__decap_3
XFILLER_48_324 VGND VGND VPWR VPWR sky130_fd_sc_hd__decap_3
XFILLER_48_357 VGND VGND VPWR VPWR sky130_fd_sc_hd__decap_3
XTAP_TAPCELL_ROW_18_238 VGND VPWR sky130_fd_sc_hd__tapvpwrvgnd_1
XFILLER_16_221 VGND VGND VPWR VPWR sky130_fd_sc_hd__decap_3
XFILLER_31_213 VGND VGND VPWR VPWR sky130_fd_sc_hd__decap_3
XFILLER_16_298 VGND VGND VPWR VPWR sky130_fd_sc_hd__decap_3
XFILLER_16_287 VGND VGND VPWR VPWR sky130_fd_sc_hd__decap_3
XFILLER_31_257 VGND VGND VPWR VPWR sky130_fd_sc_hd__decap_3
X_1700_ _1644_/A _1643_/B _1643_/C VGND VGND VPWR VPWR _1700_/X sky130_fd_sc_hd__o21a_1
X_2680_ _2616_/Y _2618_/Y _2679_/Y VGND VGND VPWR VPWR _2680_/Y sky130_fd_sc_hd__a21oi_1
X_1631_ _1631_/A _1631_/B VGND VGND VPWR VPWR _1633_/C sky130_fd_sc_hd__xnor2_1
X_1562_ _1743_/S _1754_/B _1562_/S VGND VGND VPWR VPWR _1563_/B sky130_fd_sc_hd__mux2_1
X_1493_ _2754_/A _1494_/B VGND VGND VPWR VPWR _1681_/B sky130_fd_sc_hd__xor2_2
XFILLER_3_180 VGND VGND VPWR VPWR sky130_fd_sc_hd__decap_3
XFILLER_39_335 VGND VGND VPWR VPWR sky130_fd_sc_hd__fill_1
X_2114_ _2114_/A _2114_/B VGND VGND VPWR VPWR _2121_/A sky130_fd_sc_hd__nor2_1
XFILLER_39_346 VGND VGND VPWR VPWR sky130_fd_sc_hd__decap_3
XTAP_TAPCELL_ROW_1_139 VGND VPWR sky130_fd_sc_hd__tapvpwrvgnd_1
XFILLER_54_327 VGND VGND VPWR VPWR sky130_fd_sc_hd__decap_3
X_2045_ _2222_/A _2045_/B _2726_/A VGND VGND VPWR VPWR _2048_/A sky130_fd_sc_hd__or3_1
Xfanout28 _1445_/X VGND VGND VPWR VPWR _1820_/B sky130_fd_sc_hd__buf_2
Xfanout39 _2466_/Y VGND VGND VPWR VPWR _2669_/B sky130_fd_sc_hd__buf_2
XFILLER_22_268 VGND VGND VPWR VPWR sky130_fd_sc_hd__decap_3
XFILLER_22_235 VGND VGND VPWR VPWR sky130_fd_sc_hd__decap_3
XFILLER_13_27 VGND VGND VPWR VPWR sky130_fd_sc_hd__fill_1
XFILLER_13_38 VGND VGND VPWR VPWR sky130_fd_sc_hd__decap_3
X_1829_ _1829_/A _1829_/B VGND VGND VPWR VPWR _1831_/B sky130_fd_sc_hd__xnor2_1
XFILLER_8_9 VGND VGND VPWR VPWR sky130_fd_sc_hd__decap_3
XFILLER_57_110 VGND VGND VPWR VPWR sky130_fd_sc_hd__fill_2
XFILLER_54_12 VGND VGND VPWR VPWR sky130_fd_sc_hd__decap_3
XFILLER_54_56 VGND VGND VPWR VPWR sky130_fd_sc_hd__decap_3
XTAP_TAPCELL_ROW_15_219 VGND VPWR sky130_fd_sc_hd__tapvpwrvgnd_1
XFILLER_54_67 VGND VGND VPWR VPWR sky130_fd_sc_hd__decap_3
XFILLER_0_150 VGND VGND VPWR VPWR sky130_fd_sc_hd__decap_3
XFILLER_0_172 VGND VGND VPWR VPWR sky130_fd_sc_hd__decap_3
XFILLER_48_121 VGND VGND VPWR VPWR sky130_fd_sc_hd__fill_2
XFILLER_48_187 VGND VGND VPWR VPWR sky130_fd_sc_hd__decap_3
XFILLER_51_308 VGND VGND VPWR VPWR sky130_fd_sc_hd__decap_3
XFILLER_12_290 VGND VGND VPWR VPWR sky130_fd_sc_hd__decap_3
X_2732_ _2732_/A _2777_/Q _2761_/B VGND VGND VPWR VPWR _2735_/B sky130_fd_sc_hd__and3_1
X_2663_ _2663_/A _2665_/B VGND VGND VPWR VPWR _2663_/Y sky130_fd_sc_hd__nand2_1
XFILLER_8_283 VGND VGND VPWR VPWR sky130_fd_sc_hd__decap_3
X_1614_ _1614_/A _1614_/B VGND VGND VPWR VPWR _1645_/B sky130_fd_sc_hd__xnor2_2
X_2594_ _2593_/A _2603_/A _2593_/C _2524_/X _2519_/X VGND VGND VPWR VPWR _2646_/C
+ sky130_fd_sc_hd__o311ai_4
X_1545_ _1546_/B _1546_/C _1774_/A VGND VGND VPWR VPWR _1547_/A sky130_fd_sc_hd__a21oi_1
XFILLER_5_72 VGND VGND VPWR VPWR sky130_fd_sc_hd__decap_3
X_1476_ _1677_/A _1704_/B _1899_/A VGND VGND VPWR VPWR _1690_/B sky130_fd_sc_hd__a21o_1
XFILLER_39_110 VGND VGND VPWR VPWR sky130_fd_sc_hd__fill_2
XFILLER_39_143 VGND VGND VPWR VPWR sky130_fd_sc_hd__decap_3
X_2028_ _2098_/A _2098_/B VGND VGND VPWR VPWR _2028_/Y sky130_fd_sc_hd__nor2_1
XTAP_TAPCELL_ROW_37_355 VGND VPWR sky130_fd_sc_hd__tapvpwrvgnd_1
XFILLER_54_157 VGND VGND VPWR VPWR sky130_fd_sc_hd__decap_3
XFILLER_54_146 VGND VGND VPWR VPWR sky130_fd_sc_hd__fill_2
XFILLER_50_330 VGND VGND VPWR VPWR sky130_fd_sc_hd__decap_3
XFILLER_10_227 VGND VGND VPWR VPWR sky130_fd_sc_hd__decap_3
XFILLER_6_6 VGND VGND VPWR VPWR sky130_fd_sc_hd__decap_3
XFILLER_49_12 VGND VGND VPWR VPWR sky130_fd_sc_hd__decap_3
XFILLER_49_78 VGND VGND VPWR VPWR sky130_fd_sc_hd__decap_3
XTAP_TAPCELL_ROW_28_300 VGND VPWR sky130_fd_sc_hd__tapvpwrvgnd_1
XFILLER_45_113 VGND VGND VPWR VPWR sky130_fd_sc_hd__decap_3
XFILLER_45_157 VGND VGND VPWR VPWR sky130_fd_sc_hd__fill_2
XFILLER_33_308 VGND VGND VPWR VPWR sky130_fd_sc_hd__decap_3
XFILLER_60_116 VGND VGND VPWR VPWR sky130_fd_sc_hd__decap_3
XFILLER_41_330 VGND VGND VPWR VPWR sky130_fd_sc_hd__decap_3
XFILLER_60_9 VGND VGND VPWR VPWR sky130_fd_sc_hd__decap_3
XFILLER_5_253 VGND VGND VPWR VPWR sky130_fd_sc_hd__decap_3
XFILLER_39_6 VGND VGND VPWR VPWR sky130_fd_sc_hd__decap_3
Xinput7 uio_in[1] VGND VGND VPWR VPWR input7/X sky130_fd_sc_hd__clkbuf_1
XFILLER_36_124 VGND VGND VPWR VPWR sky130_fd_sc_hd__decap_3
XFILLER_36_179 VGND VGND VPWR VPWR sky130_fd_sc_hd__decap_3
XTAP_TAPCELL_ROW_34_336 VGND VPWR sky130_fd_sc_hd__tapvpwrvgnd_1
XFILLER_32_341 VGND VGND VPWR VPWR sky130_fd_sc_hd__decap_3
XTAP_TAPCELL_ROW_42_380 VGND VPWR sky130_fd_sc_hd__tapvpwrvgnd_1
X_2715_ _2632_/C _2706_/X _2714_/Y VGND VGND VPWR VPWR _2715_/X sky130_fd_sc_hd__o21a_1
X_2646_ _2660_/A _2646_/B _2646_/C VGND VGND VPWR VPWR _2646_/X sky130_fd_sc_hd__and3b_1
X_2577_ _2577_/A _2577_/B VGND VGND VPWR VPWR _2605_/B sky130_fd_sc_hd__xnor2_1
X_1528_ _1531_/B _1528_/B VGND VGND VPWR VPWR _1601_/B sky130_fd_sc_hd__or2_1
XFILLER_59_216 VGND VGND VPWR VPWR sky130_fd_sc_hd__decap_3
X_1459_ _1460_/A _1460_/B VGND VGND VPWR VPWR _1502_/B sky130_fd_sc_hd__nand2_1
XFILLER_59_249 VGND VGND VPWR VPWR sky130_fd_sc_hd__decap_3
XFILLER_19_15 VGND VGND VPWR VPWR sky130_fd_sc_hd__fill_2
XFILLER_27_113 VGND VGND VPWR VPWR sky130_fd_sc_hd__fill_2
XFILLER_27_102 VGND VGND VPWR VPWR sky130_fd_sc_hd__fill_1
XFILLER_27_157 VGND VGND VPWR VPWR sky130_fd_sc_hd__decap_3
XFILLER_35_190 VGND VGND VPWR VPWR sky130_fd_sc_hd__decap_3
XFILLER_51_35 VGND VGND VPWR VPWR sky130_fd_sc_hd__decap_3
XFILLER_51_24 VGND VGND VPWR VPWR sky130_fd_sc_hd__decap_3
XFILLER_50_182 VGND VGND VPWR VPWR sky130_fd_sc_hd__decap_3
XFILLER_50_171 VGND VGND VPWR VPWR sky130_fd_sc_hd__decap_3
XFILLER_51_57 VGND VGND VPWR VPWR sky130_fd_sc_hd__decap_3
XFILLER_51_46 VGND VGND VPWR VPWR sky130_fd_sc_hd__decap_3
XFILLER_4_3 VGND VGND VPWR VPWR sky130_fd_sc_hd__decap_3
XFILLER_2_289 VGND VGND VPWR VPWR sky130_fd_sc_hd__decap_3
XTAP_TAPCELL_ROW_48_417 VGND VPWR sky130_fd_sc_hd__tapvpwrvgnd_1
XFILLER_58_271 VGND VGND VPWR VPWR sky130_fd_sc_hd__decap_3
XFILLER_18_124 VGND VGND VPWR VPWR sky130_fd_sc_hd__decap_3
XFILLER_33_116 VGND VGND VPWR VPWR sky130_fd_sc_hd__decap_3
XFILLER_14_352 VGND VGND VPWR VPWR sky130_fd_sc_hd__decap_3
XTAP_TAPCELL_ROW_31_317 VGND VPWR sky130_fd_sc_hd__tapvpwrvgnd_1
XFILLER_41_182 VGND VGND VPWR VPWR sky130_fd_sc_hd__decap_3
XFILLER_25_91 VGND VGND VPWR VPWR sky130_fd_sc_hd__decap_3
X_2500_ _2653_/B _2512_/B VGND VGND VPWR VPWR _2500_/Y sky130_fd_sc_hd__nand2_1
XFILLER_41_90 VGND VGND VPWR VPWR sky130_fd_sc_hd__decap_3
X_2431_ _2431_/A _2435_/A _2431_/C VGND VGND VPWR VPWR _2432_/B sky130_fd_sc_hd__or3_1
X_2362_ _2402_/A _2402_/B _2329_/X VGND VGND VPWR VPWR _2398_/A sky130_fd_sc_hd__a21o_2
XFILLER_37_3 VGND VGND VPWR VPWR sky130_fd_sc_hd__decap_3
X_2293_ _2293_/A _2293_/B _2293_/C VGND VGND VPWR VPWR _2295_/B sky130_fd_sc_hd__nand3_1
XFILLER_49_260 VGND VGND VPWR VPWR sky130_fd_sc_hd__decap_3
XFILLER_2_62 VGND VGND VPWR VPWR sky130_fd_sc_hd__decap_3
XFILLER_49_293 VGND VGND VPWR VPWR sky130_fd_sc_hd__decap_3
X_2629_ _2627_/A _2629_/B VGND VGND VPWR VPWR _2632_/B sky130_fd_sc_hd__and2b_1
XFILLER_46_24 VGND VGND VPWR VPWR sky130_fd_sc_hd__decap_3
XFILLER_55_252 VGND VGND VPWR VPWR sky130_fd_sc_hd__decap_3
XFILLER_46_46 VGND VGND VPWR VPWR sky130_fd_sc_hd__fill_1
XFILLER_46_35 VGND VGND VPWR VPWR sky130_fd_sc_hd__decap_3
XFILLER_15_116 VGND VGND VPWR VPWR sky130_fd_sc_hd__decap_3
XFILLER_55_296 VGND VGND VPWR VPWR sky130_fd_sc_hd__decap_3
XFILLER_15_149 VGND VGND VPWR VPWR sky130_fd_sc_hd__fill_2
XFILLER_11_311 VGND VGND VPWR VPWR sky130_fd_sc_hd__decap_3
XFILLER_23_182 VGND VGND VPWR VPWR sky130_fd_sc_hd__decap_3
XFILLER_7_304 VGND VGND VPWR VPWR sky130_fd_sc_hd__decap_3
XFILLER_7_18 VGND VGND VPWR VPWR sky130_fd_sc_hd__decap_3
XFILLER_7_337 VGND VGND VPWR VPWR sky130_fd_sc_hd__fill_2
XFILLER_11_71 VGND VGND VPWR VPWR sky130_fd_sc_hd__decap_3
XFILLER_38_219 VGND VGND VPWR VPWR sky130_fd_sc_hd__decap_3
X_1931_ _1931_/A _1931_/B VGND VGND VPWR VPWR _1932_/B sky130_fd_sc_hd__xnor2_1
XFILLER_21_119 VGND VGND VPWR VPWR sky130_fd_sc_hd__decap_3
X_1862_ _1727_/A _1722_/B _1722_/C VGND VGND VPWR VPWR _1863_/B sky130_fd_sc_hd__o21a_1
Xinput10 uio_in[4] VGND VGND VPWR VPWR _2407_/A sky130_fd_sc_hd__clkbuf_1
X_1793_ _1780_/Y _1782_/X _1790_/X _1781_/Y VGND VGND VPWR VPWR _1793_/X sky130_fd_sc_hd__a211o_1
X_2414_ _2380_/A _2383_/A _2372_/X _2017_/Y _2370_/X VGND VGND VPWR VPWR _2414_/X
+ sky130_fd_sc_hd__a221o_1
X_2345_ _2354_/A _2354_/B VGND VGND VPWR VPWR _2355_/A sky130_fd_sc_hd__or2_1
X_2276_ _2282_/A _2282_/B _2273_/X VGND VGND VPWR VPWR _2278_/B sky130_fd_sc_hd__a21oi_1
XFILLER_29_219 VGND VGND VPWR VPWR sky130_fd_sc_hd__decap_3
XFILLER_52_233 VGND VGND VPWR VPWR sky130_fd_sc_hd__decap_3
XFILLER_37_296 VGND VGND VPWR VPWR sky130_fd_sc_hd__fill_2
XFILLER_16_38 VGND VGND VPWR VPWR sky130_fd_sc_hd__decap_3
XFILLER_16_27 VGND VGND VPWR VPWR sky130_fd_sc_hd__fill_1
XFILLER_52_277 VGND VGND VPWR VPWR sky130_fd_sc_hd__decap_3
XFILLER_32_26 VGND VGND VPWR VPWR sky130_fd_sc_hd__fill_2
XFILLER_20_141 VGND VGND VPWR VPWR sky130_fd_sc_hd__decap_3
XFILLER_32_59 VGND VGND VPWR VPWR sky130_fd_sc_hd__decap_3
XFILLER_20_152 VGND VGND VPWR VPWR sky130_fd_sc_hd__decap_3
XFILLER_4_307 VGND VGND VPWR VPWR sky130_fd_sc_hd__fill_1
XFILLER_57_12 VGND VGND VPWR VPWR sky130_fd_sc_hd__decap_3
XFILLER_57_45 VGND VGND VPWR VPWR sky130_fd_sc_hd__decap_3
XFILLER_57_89 VGND VGND VPWR VPWR sky130_fd_sc_hd__decap_3
XFILLER_28_274 VGND VGND VPWR VPWR sky130_fd_sc_hd__fill_1
XFILLER_43_211 VGND VGND VPWR VPWR sky130_fd_sc_hd__decap_3
XFILLER_43_244 VGND VGND VPWR VPWR sky130_fd_sc_hd__decap_3
XFILLER_11_141 VGND VGND VPWR VPWR sky130_fd_sc_hd__decap_3
XFILLER_11_196 VGND VGND VPWR VPWR sky130_fd_sc_hd__decap_3
XFILLER_7_156 VGND VGND VPWR VPWR sky130_fd_sc_hd__fill_1
XFILLER_7_134 VGND VGND VPWR VPWR sky130_fd_sc_hd__decap_3
XFILLER_3_340 VGND VGND VPWR VPWR sky130_fd_sc_hd__decap_3
XFILLER_21_6 VGND VGND VPWR VPWR sky130_fd_sc_hd__fill_1
X_2130_ _2130_/A _2130_/B VGND VGND VPWR VPWR _2131_/C sky130_fd_sc_hd__xnor2_1
X_2061_ _2040_/A _2040_/B _2038_/Y VGND VGND VPWR VPWR _2064_/A sky130_fd_sc_hd__a21bo_1
XFILLER_19_263 VGND VGND VPWR VPWR sky130_fd_sc_hd__fill_2
XFILLER_34_222 VGND VGND VPWR VPWR sky130_fd_sc_hd__decap_3
XFILLER_19_296 VGND VGND VPWR VPWR sky130_fd_sc_hd__decap_3
XFILLER_34_299 VGND VGND VPWR VPWR sky130_fd_sc_hd__fill_2
XFILLER_34_277 VGND VGND VPWR VPWR sky130_fd_sc_hd__decap_3
X_1914_ _1915_/A _1915_/B _1915_/C VGND VGND VPWR VPWR _1934_/A sky130_fd_sc_hd__o21a_1
XFILLER_8_50 VGND VGND VPWR VPWR sky130_fd_sc_hd__decap_3
X_1845_ _1847_/A _1847_/B VGND VGND VPWR VPWR _1851_/A sky130_fd_sc_hd__nor2_1
XFILLER_8_94 VGND VGND VPWR VPWR sky130_fd_sc_hd__decap_3
XFILLER_8_83 VGND VGND VPWR VPWR sky130_fd_sc_hd__fill_1
X_1776_ _1776_/A _1776_/B _1776_/C VGND VGND VPWR VPWR _1777_/B sky130_fd_sc_hd__nand3_1
X_2328_ _2328_/A _2328_/B VGND VGND VPWR VPWR _2330_/B sky130_fd_sc_hd__xnor2_2
XFILLER_57_314 VGND VGND VPWR VPWR sky130_fd_sc_hd__decap_3
XFILLER_57_358 VGND VGND VPWR VPWR sky130_fd_sc_hd__decap_3
X_2259_ _2259_/A _2259_/B _2259_/C VGND VGND VPWR VPWR _2272_/A sky130_fd_sc_hd__and3_1
XFILLER_25_222 VGND VGND VPWR VPWR sky130_fd_sc_hd__fill_2
XFILLER_25_255 VGND VGND VPWR VPWR sky130_fd_sc_hd__decap_3
XFILLER_25_299 VGND VGND VPWR VPWR sky130_fd_sc_hd__decap_3
XFILLER_25_277 VGND VGND VPWR VPWR sky130_fd_sc_hd__decap_3
XFILLER_40_258 VGND VGND VPWR VPWR sky130_fd_sc_hd__decap_3
XFILLER_40_236 VGND VGND VPWR VPWR sky130_fd_sc_hd__decap_3
XFILLER_4_115 VGND VGND VPWR VPWR sky130_fd_sc_hd__decap_3
XFILLER_0_343 VGND VGND VPWR VPWR sky130_fd_sc_hd__decap_3
XFILLER_48_336 VGND VGND VPWR VPWR sky130_fd_sc_hd__decap_3
XTAP_TAPCELL_ROW_18_239 VGND VPWR sky130_fd_sc_hd__tapvpwrvgnd_1
XFILLER_31_225 VGND VGND VPWR VPWR sky130_fd_sc_hd__decap_3
XFILLER_31_269 VGND VGND VPWR VPWR sky130_fd_sc_hd__decap_3
X_1630_ _1655_/A _1655_/B VGND VGND VPWR VPWR _1633_/B sky130_fd_sc_hd__nand2_1
X_1561_ _1561_/A _1561_/B VGND VGND VPWR VPWR _1754_/B sky130_fd_sc_hd__nand2_1
X_1492_ _2057_/A _2356_/A VGND VGND VPWR VPWR _1995_/A sky130_fd_sc_hd__nor2_2
XFILLER_39_303 VGND VGND VPWR VPWR sky130_fd_sc_hd__decap_3
X_2113_ _2264_/A _2113_/B VGND VGND VPWR VPWR _2114_/B sky130_fd_sc_hd__and2_1
XFILLER_39_358 VGND VGND VPWR VPWR sky130_fd_sc_hd__decap_3
XFILLER_54_306 VGND VGND VPWR VPWR sky130_fd_sc_hd__fill_2
X_2044_ _1981_/B _2042_/X _2041_/X _2031_/Y VGND VGND VPWR VPWR _2066_/B sky130_fd_sc_hd__o211a_1
XFILLER_54_339 VGND VGND VPWR VPWR sky130_fd_sc_hd__decap_3
Xfanout29 _1878_/A VGND VGND VPWR VPWR _1809_/A sky130_fd_sc_hd__buf_2
XFILLER_22_225 VGND VGND VPWR VPWR sky130_fd_sc_hd__decap_3
XFILLER_22_203 VGND VGND VPWR VPWR sky130_fd_sc_hd__decap_3
XFILLER_22_247 VGND VGND VPWR VPWR sky130_fd_sc_hd__decap_3
XFILLER_30_291 VGND VGND VPWR VPWR sky130_fd_sc_hd__fill_1
X_1828_ _1813_/A _1813_/B _1814_/Y VGND VGND VPWR VPWR _1831_/A sky130_fd_sc_hd__a21bo_1
X_1759_ _1752_/A _1771_/B _1580_/B VGND VGND VPWR VPWR _1765_/B sky130_fd_sc_hd__o21ba_1
XFILLER_1_107 VGND VGND VPWR VPWR sky130_fd_sc_hd__decap_3
XFILLER_57_122 VGND VGND VPWR VPWR sky130_fd_sc_hd__decap_3
XFILLER_57_166 VGND VGND VPWR VPWR sky130_fd_sc_hd__fill_2
XFILLER_60_309 VGND VGND VPWR VPWR sky130_fd_sc_hd__decap_3
XFILLER_54_35 VGND VGND VPWR VPWR sky130_fd_sc_hd__decap_3
XFILLER_54_24 VGND VGND VPWR VPWR sky130_fd_sc_hd__decap_3
XFILLER_54_79 VGND VGND VPWR VPWR sky130_fd_sc_hd__decap_3
XFILLER_13_236 VGND VGND VPWR VPWR sky130_fd_sc_hd__fill_1
XFILLER_13_258 VGND VGND VPWR VPWR sky130_fd_sc_hd__decap_3
XFILLER_0_162 VGND VGND VPWR VPWR sky130_fd_sc_hd__fill_1
XFILLER_0_184 VGND VGND VPWR VPWR sky130_fd_sc_hd__decap_3
XFILLER_48_144 VGND VGND VPWR VPWR sky130_fd_sc_hd__decap_3
XFILLER_48_166 VGND VGND VPWR VPWR sky130_fd_sc_hd__decap_3
XFILLER_28_91 VGND VGND VPWR VPWR sky130_fd_sc_hd__fill_1
XFILLER_44_350 VGND VGND VPWR VPWR sky130_fd_sc_hd__decap_3
X_2731_ _2777_/Q _2761_/B _2732_/A VGND VGND VPWR VPWR _2733_/A sky130_fd_sc_hd__a21oi_1
XFILLER_8_262 VGND VGND VPWR VPWR sky130_fd_sc_hd__fill_1
XFILLER_8_251 VGND VGND VPWR VPWR sky130_fd_sc_hd__fill_1
X_2662_ _2662_/A _2662_/B _2662_/C VGND VGND VPWR VPWR _2665_/B sky130_fd_sc_hd__nor3_1
X_1613_ _1613_/A _1613_/B VGND VGND VPWR VPWR _1645_/A sky130_fd_sc_hd__xor2_2
X_2593_ _2593_/A _2603_/A _2593_/C VGND VGND VPWR VPWR _2593_/X sky130_fd_sc_hd__or3_1
X_1544_ _1613_/B _1613_/A VGND VGND VPWR VPWR _1546_/C sky130_fd_sc_hd__nand2b_1
X_1475_ _2441_/A _1475_/B VGND VGND VPWR VPWR _2217_/B sky130_fd_sc_hd__xnor2_2
XFILLER_39_155 VGND VGND VPWR VPWR sky130_fd_sc_hd__decap_3
XFILLER_54_103 VGND VGND VPWR VPWR sky130_fd_sc_hd__decap_3
XFILLER_27_328 VGND VGND VPWR VPWR sky130_fd_sc_hd__decap_3
X_2027_ _2096_/A _2027_/B VGND VGND VPWR VPWR _2098_/B sky130_fd_sc_hd__xor2_1
XFILLER_42_309 VGND VGND VPWR VPWR sky130_fd_sc_hd__decap_3
XFILLER_50_342 VGND VGND VPWR VPWR sky130_fd_sc_hd__decap_3
XFILLER_40_15 VGND VGND VPWR VPWR sky130_fd_sc_hd__decap_3
XFILLER_49_24 VGND VGND VPWR VPWR sky130_fd_sc_hd__decap_3
XTAP_TAPCELL_ROW_28_301 VGND VPWR sky130_fd_sc_hd__tapvpwrvgnd_1
XFILLER_45_125 VGND VGND VPWR VPWR sky130_fd_sc_hd__decap_3
XFILLER_45_169 VGND VGND VPWR VPWR sky130_fd_sc_hd__decap_3
XFILLER_60_128 VGND VGND VPWR VPWR sky130_fd_sc_hd__decap_3
XFILLER_60_106 VGND VGND VPWR VPWR sky130_fd_sc_hd__decap_3
XFILLER_53_191 VGND VGND VPWR VPWR sky130_fd_sc_hd__decap_3
XFILLER_5_210 VGND VGND VPWR VPWR sky130_fd_sc_hd__decap_3
XFILLER_53_9 VGND VGND VPWR VPWR sky130_fd_sc_hd__decap_3
XFILLER_5_298 VGND VGND VPWR VPWR sky130_fd_sc_hd__fill_1
XFILLER_5_287 VGND VGND VPWR VPWR sky130_fd_sc_hd__decap_3
XFILLER_5_276 VGND VGND VPWR VPWR sky130_fd_sc_hd__decap_3
XFILLER_30_92 VGND VGND VPWR VPWR sky130_fd_sc_hd__decap_3
XFILLER_30_70 VGND VGND VPWR VPWR sky130_fd_sc_hd__decap_3
Xinput8 uio_in[2] VGND VGND VPWR VPWR input8/X sky130_fd_sc_hd__clkbuf_1
XFILLER_36_147 VGND VGND VPWR VPWR sky130_fd_sc_hd__fill_2
XFILLER_36_136 VGND VGND VPWR VPWR sky130_fd_sc_hd__decap_3
XFILLER_51_128 VGND VGND VPWR VPWR sky130_fd_sc_hd__decap_3
XFILLER_51_106 VGND VGND VPWR VPWR sky130_fd_sc_hd__fill_2
XTAP_TAPCELL_ROW_34_337 VGND VPWR sky130_fd_sc_hd__tapvpwrvgnd_1
XFILLER_51_139 VGND VGND VPWR VPWR sky130_fd_sc_hd__decap_3
XFILLER_44_191 VGND VGND VPWR VPWR sky130_fd_sc_hd__decap_3
XTAP_TAPCELL_ROW_42_381 VGND VPWR sky130_fd_sc_hd__tapvpwrvgnd_1
X_2714_ _2632_/C _2706_/X _2669_/B VGND VGND VPWR VPWR _2714_/Y sky130_fd_sc_hd__a21oi_1
X_2645_ _2524_/X _2593_/X _2519_/X VGND VGND VPWR VPWR _2646_/B sky130_fd_sc_hd__a21o_1
XFILLER_10_29 VGND VGND VPWR VPWR sky130_fd_sc_hd__decap_3
X_2576_ _2607_/A _2611_/A _2568_/X VGND VGND VPWR VPWR _2605_/A sky130_fd_sc_hd__a21o_1
X_1527_ _1878_/A _1582_/A _1584_/B VGND VGND VPWR VPWR _1528_/B sky130_fd_sc_hd__o21a_1
XFILLER_59_228 VGND VGND VPWR VPWR sky130_fd_sc_hd__decap_3
X_1458_ _1535_/A _1986_/B _1517_/A VGND VGND VPWR VPWR _1460_/B sky130_fd_sc_hd__o21a_1
X_1389_ _1442_/B _1473_/B _2765_/Q _2764_/Q VGND VGND VPWR VPWR _1427_/B sky130_fd_sc_hd__and4b_4
XFILLER_35_15 VGND VGND VPWR VPWR sky130_fd_sc_hd__decap_3
XFILLER_27_169 VGND VGND VPWR VPWR sky130_fd_sc_hd__decap_3
XFILLER_15_309 VGND VGND VPWR VPWR sky130_fd_sc_hd__decap_3
XFILLER_50_150 VGND VGND VPWR VPWR sky130_fd_sc_hd__fill_1
XFILLER_50_194 VGND VGND VPWR VPWR sky130_fd_sc_hd__fill_2
XFILLER_51_69 VGND VGND VPWR VPWR sky130_fd_sc_hd__decap_3
XFILLER_2_213 VGND VGND VPWR VPWR sky130_fd_sc_hd__decap_3
XTAP_TAPCELL_ROW_48_418 VGND VPWR sky130_fd_sc_hd__tapvpwrvgnd_1
XFILLER_58_283 VGND VGND VPWR VPWR sky130_fd_sc_hd__decap_3
XFILLER_25_70 VGND VGND VPWR VPWR sky130_fd_sc_hd__decap_3
XTAP_TAPCELL_ROW_31_318 VGND VPWR sky130_fd_sc_hd__tapvpwrvgnd_1
XFILLER_41_194 VGND VGND VPWR VPWR sky130_fd_sc_hd__decap_3
X_2430_ _2761_/A _2430_/B VGND VGND VPWR VPWR _2700_/A sky130_fd_sc_hd__xnor2_1
XFILLER_51_6 VGND VGND VPWR VPWR sky130_fd_sc_hd__decap_3
X_2361_ _2484_/A _2484_/B _2343_/X VGND VGND VPWR VPWR _2402_/B sky130_fd_sc_hd__a21o_1
X_2292_ _2292_/A _2292_/B _2292_/C VGND VGND VPWR VPWR _2293_/C sky130_fd_sc_hd__or3_1
XFILLER_56_209 VGND VGND VPWR VPWR sky130_fd_sc_hd__decap_3
XFILLER_2_41 VGND VGND VPWR VPWR sky130_fd_sc_hd__decap_3
XFILLER_49_272 VGND VGND VPWR VPWR sky130_fd_sc_hd__decap_3
XFILLER_24_139 VGND VGND VPWR VPWR sky130_fd_sc_hd__fill_1
XFILLER_17_180 VGND VGND VPWR VPWR sky130_fd_sc_hd__decap_3
XFILLER_32_183 VGND VGND VPWR VPWR sky130_fd_sc_hd__fill_1
XFILLER_32_161 VGND VGND VPWR VPWR sky130_fd_sc_hd__decap_3
XFILLER_20_312 VGND VGND VPWR VPWR sky130_fd_sc_hd__decap_3
XFILLER_20_301 VGND VGND VPWR VPWR sky130_fd_sc_hd__decap_3
XFILLER_32_194 VGND VGND VPWR VPWR sky130_fd_sc_hd__fill_2
X_2628_ _2628_/A _2628_/B VGND VGND VPWR VPWR _2629_/B sky130_fd_sc_hd__xnor2_1
X_2559_ _2557_/X _2559_/B VGND VGND VPWR VPWR _2623_/A sky130_fd_sc_hd__nand2b_1
XFILLER_47_209 VGND VGND VPWR VPWR sky130_fd_sc_hd__fill_2
XFILLER_55_231 VGND VGND VPWR VPWR sky130_fd_sc_hd__decap_3
XFILLER_55_220 VGND VGND VPWR VPWR sky130_fd_sc_hd__decap_3
XFILLER_55_264 VGND VGND VPWR VPWR sky130_fd_sc_hd__decap_3
XFILLER_15_106 VGND VGND VPWR VPWR sky130_fd_sc_hd__decap_3
XFILLER_23_150 VGND VGND VPWR VPWR sky130_fd_sc_hd__decap_3
XFILLER_7_327 VGND VGND VPWR VPWR sky130_fd_sc_hd__decap_3
XFILLER_7_316 VGND VGND VPWR VPWR sky130_fd_sc_hd__fill_1
XFILLER_46_231 VGND VGND VPWR VPWR sky130_fd_sc_hd__decap_3
XFILLER_46_264 VGND VGND VPWR VPWR sky130_fd_sc_hd__decap_3
XFILLER_46_253 VGND VGND VPWR VPWR sky130_fd_sc_hd__decap_3
XFILLER_36_91 VGND VGND VPWR VPWR sky130_fd_sc_hd__fill_1
XFILLER_14_150 VGND VGND VPWR VPWR sky130_fd_sc_hd__fill_1
XFILLER_14_161 VGND VGND VPWR VPWR sky130_fd_sc_hd__decap_3
XFILLER_14_172 VGND VGND VPWR VPWR sky130_fd_sc_hd__decap_3
X_1930_ _1931_/B _1931_/A VGND VGND VPWR VPWR _1930_/X sky130_fd_sc_hd__and2b_1
X_1861_ _1837_/A _1837_/B _1860_/Y VGND VGND VPWR VPWR _1866_/A sky130_fd_sc_hd__a21bo_1
Xinput11 uio_in[5] VGND VGND VPWR VPWR _2673_/A sky130_fd_sc_hd__buf_1
X_1792_ _1650_/X _1654_/A _1791_/X VGND VGND VPWR VPWR _1794_/B sky130_fd_sc_hd__a21o_1
XFILLER_6_360 VGND VGND VPWR VPWR sky130_fd_sc_hd__fill_1
X_2413_ _2620_/A _2473_/A _2454_/A VGND VGND VPWR VPWR _2459_/A sky130_fd_sc_hd__a21o_1
X_2344_ _2341_/A _2341_/C _2341_/B VGND VGND VPWR VPWR _2354_/B sky130_fd_sc_hd__a21oi_1
Xclkbuf_1_0__f_clk clkbuf_0_clk/X VGND VGND VPWR VPWR clkload0/A sky130_fd_sc_hd__clkbuf_16
X_2275_ _2275_/A _2275_/B VGND VGND VPWR VPWR _2282_/B sky130_fd_sc_hd__xnor2_1
XFILLER_52_256 VGND VGND VPWR VPWR sky130_fd_sc_hd__decap_3
XFILLER_52_289 VGND VGND VPWR VPWR sky130_fd_sc_hd__decap_3
XFILLER_20_164 VGND VGND VPWR VPWR sky130_fd_sc_hd__decap_3
XFILLER_20_197 VGND VGND VPWR VPWR sky130_fd_sc_hd__decap_3
XFILLER_4_319 VGND VGND VPWR VPWR sky130_fd_sc_hd__decap_3
XFILLER_57_24 VGND VGND VPWR VPWR sky130_fd_sc_hd__decap_3
XFILLER_57_57 VGND VGND VPWR VPWR sky130_fd_sc_hd__decap_3
XFILLER_28_253 VGND VGND VPWR VPWR sky130_fd_sc_hd__decap_3
XFILLER_28_242 VGND VGND VPWR VPWR sky130_fd_sc_hd__decap_3
XFILLER_43_223 VGND VGND VPWR VPWR sky130_fd_sc_hd__fill_1
XFILLER_11_120 VGND VGND VPWR VPWR sky130_fd_sc_hd__decap_3
XFILLER_11_153 VGND VGND VPWR VPWR sky130_fd_sc_hd__decap_3
XFILLER_7_113 VGND VGND VPWR VPWR sky130_fd_sc_hd__decap_3
XFILLER_7_102 VGND VGND VPWR VPWR sky130_fd_sc_hd__decap_3
XFILLER_11_175 VGND VGND VPWR VPWR sky130_fd_sc_hd__decap_3
XFILLER_22_60 VGND VGND VPWR VPWR sky130_fd_sc_hd__fill_2
XFILLER_22_82 VGND VGND VPWR VPWR sky130_fd_sc_hd__fill_2
XFILLER_3_330 VGND VGND VPWR VPWR sky130_fd_sc_hd__decap_3
XFILLER_3_352 VGND VGND VPWR VPWR sky130_fd_sc_hd__decap_3
X_2060_ _2055_/A _2056_/A _2055_/B _2059_/Y VGND VGND VPWR VPWR _2065_/A sky130_fd_sc_hd__o31ai_2
XFILLER_19_231 VGND VGND VPWR VPWR sky130_fd_sc_hd__decap_3
XFILLER_19_220 VGND VGND VPWR VPWR sky130_fd_sc_hd__decap_3
XFILLER_47_90 VGND VGND VPWR VPWR sky130_fd_sc_hd__decap_3
XFILLER_34_234 VGND VGND VPWR VPWR sky130_fd_sc_hd__decap_3
X_1913_ _1913_/A _1913_/B VGND VGND VPWR VPWR _1915_/C sky130_fd_sc_hd__nor2_1
X_1844_ _1844_/A _1844_/B VGND VGND VPWR VPWR _1847_/B sky130_fd_sc_hd__or2_1
XFILLER_8_62 VGND VGND VPWR VPWR sky130_fd_sc_hd__decap_3
X_1775_ _1775_/A _1775_/B VGND VGND VPWR VPWR _1783_/A sky130_fd_sc_hd__xnor2_1
X_2327_ _2326_/B _2332_/A VGND VGND VPWR VPWR _2330_/A sky130_fd_sc_hd__nand2b_2
XFILLER_57_326 VGND VGND VPWR VPWR sky130_fd_sc_hd__decap_3
X_2258_ _2213_/A _2212_/B _2212_/C VGND VGND VPWR VPWR _2259_/C sky130_fd_sc_hd__a21o_1
XFILLER_57_337 VGND VGND VPWR VPWR sky130_fd_sc_hd__decap_3
XFILLER_27_16 VGND VGND VPWR VPWR sky130_fd_sc_hd__decap_3
X_2189_ _2189_/A _2189_/B VGND VGND VPWR VPWR _2192_/B sky130_fd_sc_hd__xnor2_1
XFILLER_25_234 VGND VGND VPWR VPWR sky130_fd_sc_hd__decap_3
XFILLER_43_37 VGND VGND VPWR VPWR sky130_fd_sc_hd__decap_3
XFILLER_43_15 VGND VGND VPWR VPWR sky130_fd_sc_hd__decap_3
XFILLER_4_127 VGND VGND VPWR VPWR sky130_fd_sc_hd__decap_3
XFILLER_0_322 VGND VGND VPWR VPWR sky130_fd_sc_hd__fill_2
XFILLER_0_333 VGND VGND VPWR VPWR sky130_fd_sc_hd__decap_3
XFILLER_0_355 VGND VGND VPWR VPWR sky130_fd_sc_hd__decap_3
XFILLER_48_315 VGND VGND VPWR VPWR sky130_fd_sc_hd__decap_3
XFILLER_48_348 VGND VGND VPWR VPWR sky130_fd_sc_hd__decap_3
XFILLER_16_212 VGND VGND VPWR VPWR sky130_fd_sc_hd__decap_3
XFILLER_31_204 VGND VGND VPWR VPWR sky130_fd_sc_hd__decap_3
XFILLER_17_93 VGND VGND VPWR VPWR sky130_fd_sc_hd__fill_2
XTAP_TAPCELL_ROW_26_284 VGND VPWR sky130_fd_sc_hd__tapvpwrvgnd_1
X_1560_ _1562_/S _1561_/B VGND VGND VPWR VPWR _1757_/A sky130_fd_sc_hd__nand2_1
X_1491_ _1494_/B _1491_/B VGND VGND VPWR VPWR _1985_/B sky130_fd_sc_hd__or2_2
XFILLER_39_315 VGND VGND VPWR VPWR sky130_fd_sc_hd__fill_2
XFILLER_12_3 VGND VGND VPWR VPWR sky130_fd_sc_hd__decap_3
X_2112_ _2041_/X _2110_/Y _2109_/X _2099_/Y VGND VGND VPWR VPWR _2131_/B sky130_fd_sc_hd__a211oi_2
XFILLER_39_337 VGND VGND VPWR VPWR sky130_fd_sc_hd__decap_3
XFILLER_54_318 VGND VGND VPWR VPWR sky130_fd_sc_hd__decap_3
X_2043_ _2031_/Y _2041_/X _2042_/X _1981_/B VGND VGND VPWR VPWR _2066_/A sky130_fd_sc_hd__a211oi_2
XFILLER_22_259 VGND VGND VPWR VPWR sky130_fd_sc_hd__decap_3
XFILLER_13_18 VGND VGND VPWR VPWR sky130_fd_sc_hd__decap_3
X_1827_ _1907_/A _1907_/B _1825_/Y VGND VGND VPWR VPWR _1833_/A sky130_fd_sc_hd__a21bo_1
X_1758_ _1762_/C _1758_/B VGND VGND VPWR VPWR _1771_/B sky130_fd_sc_hd__nand2_1
X_1689_ _1899_/A _1682_/B _1683_/B _1683_/A VGND VGND VPWR VPWR _1692_/B sky130_fd_sc_hd__a22o_1
XFILLER_57_101 VGND VGND VPWR VPWR sky130_fd_sc_hd__decap_3
XFILLER_38_15 VGND VGND VPWR VPWR sky130_fd_sc_hd__decap_3
XFILLER_38_59 VGND VGND VPWR VPWR sky130_fd_sc_hd__fill_2
XFILLER_57_178 VGND VGND VPWR VPWR sky130_fd_sc_hd__fill_1
XTAP_TAPCELL_ROW_0_130 VGND VPWR sky130_fd_sc_hd__tapvpwrvgnd_1
XFILLER_54_47 VGND VGND VPWR VPWR sky130_fd_sc_hd__decap_3
XFILLER_53_340 VGND VGND VPWR VPWR sky130_fd_sc_hd__decap_3
XFILLER_9_219 VGND VGND VPWR VPWR sky130_fd_sc_hd__decap_3
XFILLER_21_281 VGND VGND VPWR VPWR sky130_fd_sc_hd__decap_3
XFILLER_21_292 VGND VGND VPWR VPWR sky130_fd_sc_hd__fill_1
XFILLER_0_141 VGND VGND VPWR VPWR sky130_fd_sc_hd__decap_3
XFILLER_48_112 VGND VGND VPWR VPWR sky130_fd_sc_hd__decap_3
XFILLER_36_307 VGND VGND VPWR VPWR sky130_fd_sc_hd__fill_1
XFILLER_48_178 VGND VGND VPWR VPWR sky130_fd_sc_hd__decap_3
XFILLER_44_80 VGND VGND VPWR VPWR sky130_fd_sc_hd__decap_3
XFILLER_44_91 VGND VGND VPWR VPWR sky130_fd_sc_hd__decap_3
XFILLER_12_281 VGND VGND VPWR VPWR sky130_fd_sc_hd__decap_3
X_2730_ _2776_/Q _2759_/B VGND VGND VPWR VPWR _2761_/B sky130_fd_sc_hd__and2_1
X_2661_ _2660_/B _2660_/Y _2661_/S VGND VGND VPWR VPWR _2661_/X sky130_fd_sc_hd__mux2_1
X_1612_ _1612_/A _1612_/B VGND VGND VPWR VPWR _1614_/B sky130_fd_sc_hd__nor2_1
XFILLER_8_274 VGND VGND VPWR VPWR sky130_fd_sc_hd__fill_1
X_2592_ _2593_/C VGND VGND VPWR VPWR _2592_/Y sky130_fd_sc_hd__inv_2
XFILLER_5_30 VGND VGND VPWR VPWR sky130_fd_sc_hd__decap_3
X_1543_ _1546_/B _1543_/B VGND VGND VPWR VPWR _1613_/B sky130_fd_sc_hd__nand2_1
XFILLER_5_63 VGND VGND VPWR VPWR sky130_fd_sc_hd__decap_3
X_1474_ _2774_/Q _1475_/B VGND VGND VPWR VPWR _1704_/B sky130_fd_sc_hd__xnor2_4
XFILLER_39_101 VGND VGND VPWR VPWR sky130_fd_sc_hd__decap_3
XFILLER_39_134 VGND VGND VPWR VPWR sky130_fd_sc_hd__decap_3
XFILLER_39_167 VGND VGND VPWR VPWR sky130_fd_sc_hd__fill_1
XFILLER_54_126 VGND VGND VPWR VPWR sky130_fd_sc_hd__decap_3
XFILLER_27_318 VGND VGND VPWR VPWR sky130_fd_sc_hd__decap_3
X_2026_ _2026_/A _2026_/B VGND VGND VPWR VPWR _2098_/A sky130_fd_sc_hd__xnor2_1
XFILLER_50_321 VGND VGND VPWR VPWR sky130_fd_sc_hd__decap_3
XFILLER_50_354 VGND VGND VPWR VPWR sky130_fd_sc_hd__decap_3
XFILLER_40_27 VGND VGND VPWR VPWR sky130_fd_sc_hd__fill_1
XFILLER_40_49 VGND VGND VPWR VPWR sky130_fd_sc_hd__fill_1
XFILLER_45_148 VGND VGND VPWR VPWR sky130_fd_sc_hd__decap_3
XFILLER_14_50 VGND VGND VPWR VPWR sky130_fd_sc_hd__fill_1
XFILLER_5_222 VGND VGND VPWR VPWR sky130_fd_sc_hd__fill_2
XFILLER_5_244 VGND VGND VPWR VPWR sky130_fd_sc_hd__decap_3
XFILLER_30_82 VGND VGND VPWR VPWR sky130_fd_sc_hd__fill_2
XFILLER_46_9 VGND VGND VPWR VPWR sky130_fd_sc_hd__decap_3
XFILLER_39_91 VGND VGND VPWR VPWR sky130_fd_sc_hd__decap_3
XTAP_TAPCELL_ROW_59_482 VGND VPWR sky130_fd_sc_hd__tapvpwrvgnd_1
Xinput9 uio_in[3] VGND VGND VPWR VPWR input9/X sky130_fd_sc_hd__clkbuf_1
XFILLER_36_115 VGND VGND VPWR VPWR sky130_fd_sc_hd__decap_3
XFILLER_36_159 VGND VGND VPWR VPWR sky130_fd_sc_hd__decap_3
XFILLER_32_332 VGND VGND VPWR VPWR sky130_fd_sc_hd__decap_3
XTAP_TAPCELL_ROW_42_382 VGND VPWR sky130_fd_sc_hd__tapvpwrvgnd_1
X_2713_ _2712_/Y _2712_/A _2713_/S VGND VGND VPWR VPWR _2713_/X sky130_fd_sc_hd__mux2_1
XFILLER_10_19 VGND VGND VPWR VPWR sky130_fd_sc_hd__decap_3
X_2644_ _2468_/B _2642_/X _2643_/Y _1489_/B VGND VGND VPWR VPWR _2644_/X sky130_fd_sc_hd__a31o_1
X_2575_ _2610_/A _2610_/B VGND VGND VPWR VPWR _2611_/A sky130_fd_sc_hd__nor2_1
X_1526_ _1586_/A _1951_/B _1669_/B VGND VGND VPWR VPWR _1531_/B sky130_fd_sc_hd__and3_1
X_1457_ _1557_/B _1986_/B VGND VGND VPWR VPWR _1517_/A sky130_fd_sc_hd__nand2_1
X_1388_ _1442_/B _1473_/B _2764_/Q VGND VGND VPWR VPWR _1391_/B sky130_fd_sc_hd__and3b_2
XFILLER_27_148 VGND VGND VPWR VPWR sky130_fd_sc_hd__decap_3
XFILLER_35_49 VGND VGND VPWR VPWR sky130_fd_sc_hd__decap_3
X_2009_ _1934_/A _1933_/B _1933_/C VGND VGND VPWR VPWR _2009_/X sky130_fd_sc_hd__o21a_1
XFILLER_42_129 VGND VGND VPWR VPWR sky130_fd_sc_hd__fill_2
XFILLER_35_181 VGND VGND VPWR VPWR sky130_fd_sc_hd__decap_3
XFILLER_51_15 VGND VGND VPWR VPWR sky130_fd_sc_hd__decap_3
XFILLER_50_162 VGND VGND VPWR VPWR sky130_fd_sc_hd__decap_3
XFILLER_2_247 VGND VGND VPWR VPWR sky130_fd_sc_hd__fill_2
XFILLER_2_236 VGND VGND VPWR VPWR sky130_fd_sc_hd__decap_3
XFILLER_2_269 VGND VGND VPWR VPWR sky130_fd_sc_hd__decap_3
XFILLER_58_240 VGND VGND VPWR VPWR sky130_fd_sc_hd__decap_3
XTAP_TAPCELL_ROW_48_419 VGND VPWR sky130_fd_sc_hd__tapvpwrvgnd_1
XFILLER_58_262 VGND VGND VPWR VPWR sky130_fd_sc_hd__decap_3
XFILLER_18_115 VGND VGND VPWR VPWR sky130_fd_sc_hd__decap_3
XFILLER_58_295 VGND VGND VPWR VPWR sky130_fd_sc_hd__decap_3
XFILLER_33_107 VGND VGND VPWR VPWR sky130_fd_sc_hd__decap_3
XTAP_TAPCELL_ROW_31_319 VGND VPWR sky130_fd_sc_hd__tapvpwrvgnd_1
XFILLER_41_81 VGND VGND VPWR VPWR sky130_fd_sc_hd__decap_3
XFILLER_44_6 VGND VGND VPWR VPWR sky130_fd_sc_hd__decap_3
X_2360_ _2360_/A _2360_/B VGND VGND VPWR VPWR _2484_/B sky130_fd_sc_hd__xnor2_1
X_2291_ _2264_/A _2726_/A _2214_/X _2356_/A VGND VGND VPWR VPWR _2295_/A sky130_fd_sc_hd__o211a_1
XPHY_EDGE_ROW_10_Right_10 VGND VGND VPWR VPWR sky130_fd_sc_hd__decap_3
XFILLER_49_251 VGND VGND VPWR VPWR sky130_fd_sc_hd__decap_3
XFILLER_2_53 VGND VGND VPWR VPWR sky130_fd_sc_hd__decap_3
XFILLER_49_284 VGND VGND VPWR VPWR sky130_fd_sc_hd__decap_3
XFILLER_21_29 VGND VGND VPWR VPWR sky130_fd_sc_hd__fill_1
X_2627_ _2627_/A _2627_/B VGND VGND VPWR VPWR _2707_/B sky130_fd_sc_hd__nor2_1
X_2558_ _2558_/A _2558_/B VGND VGND VPWR VPWR _2559_/B sky130_fd_sc_hd__or2_1
X_1509_ _2000_/A _1509_/B VGND VGND VPWR VPWR _1521_/C sky130_fd_sc_hd__xnor2_1
X_2489_ _2490_/A _2490_/B VGND VGND VPWR VPWR _2489_/Y sky130_fd_sc_hd__nand2_1
XFILLER_46_15 VGND VGND VPWR VPWR sky130_fd_sc_hd__decap_3
XFILLER_46_59 VGND VGND VPWR VPWR sky130_fd_sc_hd__decap_3
XFILLER_55_276 VGND VGND VPWR VPWR sky130_fd_sc_hd__decap_3
XFILLER_55_287 VGND VGND VPWR VPWR sky130_fd_sc_hd__decap_3
XFILLER_23_162 VGND VGND VPWR VPWR sky130_fd_sc_hd__fill_2
XFILLER_11_357 VGND VGND VPWR VPWR sky130_fd_sc_hd__decap_3
XFILLER_11_40 VGND VGND VPWR VPWR sky130_fd_sc_hd__fill_2
XFILLER_11_62 VGND VGND VPWR VPWR sky130_fd_sc_hd__decap_3
XFILLER_46_210 VGND VGND VPWR VPWR sky130_fd_sc_hd__decap_3
XFILLER_46_243 VGND VGND VPWR VPWR sky130_fd_sc_hd__decap_3
XFILLER_46_298 VGND VGND VPWR VPWR sky130_fd_sc_hd__decap_3
XFILLER_36_70 VGND VGND VPWR VPWR sky130_fd_sc_hd__decap_3
XFILLER_14_195 VGND VGND VPWR VPWR sky130_fd_sc_hd__fill_1
X_1860_ _1935_/A _1935_/B VGND VGND VPWR VPWR _1860_/Y sky130_fd_sc_hd__nand2b_1
XPHY_EDGE_ROW_26_Left_87 VGND VGND VPWR VPWR sky130_fd_sc_hd__decap_3
X_1791_ _1791_/A _1791_/B VGND VGND VPWR VPWR _1791_/X sky130_fd_sc_hd__xor2_1
Xinput12 uio_in[6] VGND VGND VPWR VPWR _2384_/A sky130_fd_sc_hd__buf_1
X_2412_ _2453_/B _2456_/A _2453_/A VGND VGND VPWR VPWR _2454_/A sky130_fd_sc_hd__a21oi_1
XFILLER_42_3 VGND VGND VPWR VPWR sky130_fd_sc_hd__decap_3
X_2343_ _2360_/B _2360_/A VGND VGND VPWR VPWR _2343_/X sky130_fd_sc_hd__and2b_1
X_2274_ _2293_/A _2270_/B _2268_/Y VGND VGND VPWR VPWR _2282_/A sky130_fd_sc_hd__o21ai_1
XFILLER_37_232 VGND VGND VPWR VPWR sky130_fd_sc_hd__fill_1
XFILLER_37_276 VGND VGND VPWR VPWR sky130_fd_sc_hd__decap_3
XFILLER_52_224 VGND VGND VPWR VPWR sky130_fd_sc_hd__decap_3
XFILLER_52_213 VGND VGND VPWR VPWR sky130_fd_sc_hd__decap_3
XFILLER_16_29 VGND VGND VPWR VPWR sky130_fd_sc_hd__fill_1
XFILLER_52_268 VGND VGND VPWR VPWR sky130_fd_sc_hd__decap_3
XFILLER_52_246 VGND VGND VPWR VPWR sky130_fd_sc_hd__decap_3
XFILLER_60_290 VGND VGND VPWR VPWR sky130_fd_sc_hd__decap_3
X_1989_ _1557_/B _1986_/X _1987_/X _1916_/Y VGND VGND VPWR VPWR _1993_/B sky130_fd_sc_hd__a22o_1
XFILLER_20_176 VGND VGND VPWR VPWR sky130_fd_sc_hd__decap_3
XFILLER_4_309 VGND VGND VPWR VPWR sky130_fd_sc_hd__decap_3
XFILLER_57_36 VGND VGND VPWR VPWR sky130_fd_sc_hd__decap_3
XFILLER_11_132 VGND VGND VPWR VPWR sky130_fd_sc_hd__decap_3
XFILLER_51_290 VGND VGND VPWR VPWR sky130_fd_sc_hd__decap_3
XFILLER_7_125 VGND VGND VPWR VPWR sky130_fd_sc_hd__decap_3
XFILLER_19_254 VGND VGND VPWR VPWR sky130_fd_sc_hd__decap_3
XFILLER_34_213 VGND VGND VPWR VPWR sky130_fd_sc_hd__decap_3
XFILLER_19_287 VGND VGND VPWR VPWR sky130_fd_sc_hd__decap_3
XFILLER_34_246 VGND VGND VPWR VPWR sky130_fd_sc_hd__decap_3
X_1912_ _1835_/A _1834_/B _1834_/C VGND VGND VPWR VPWR _1913_/B sky130_fd_sc_hd__o21a_1
XFILLER_42_290 VGND VGND VPWR VPWR sky130_fd_sc_hd__fill_1
XFILLER_8_41 VGND VGND VPWR VPWR sky130_fd_sc_hd__decap_3
X_1843_ _1995_/A _1843_/B VGND VGND VPWR VPWR _1844_/B sky130_fd_sc_hd__nor2_1
XFILLER_8_85 VGND VGND VPWR VPWR sky130_fd_sc_hd__fill_2
XFILLER_8_74 VGND VGND VPWR VPWR sky130_fd_sc_hd__decap_3
X_1774_ _1774_/A _1774_/B VGND VGND VPWR VPWR _1775_/B sky130_fd_sc_hd__xnor2_1
X_2326_ _2326_/A _2326_/B _2326_/C VGND VGND VPWR VPWR _2332_/A sky130_fd_sc_hd__or3_1
XFILLER_57_305 VGND VGND VPWR VPWR sky130_fd_sc_hd__decap_3
X_2257_ _2288_/A _2288_/B _2251_/Y VGND VGND VPWR VPWR _2259_/B sky130_fd_sc_hd__a21bo_1
XFILLER_57_349 VGND VGND VPWR VPWR sky130_fd_sc_hd__decap_3
X_2188_ _2188_/A _2188_/B VGND VGND VPWR VPWR _2192_/A sky130_fd_sc_hd__nor2_1
XFILLER_25_213 VGND VGND VPWR VPWR sky130_fd_sc_hd__decap_3
XFILLER_25_202 VGND VGND VPWR VPWR sky130_fd_sc_hd__fill_1
XFILLER_25_246 VGND VGND VPWR VPWR sky130_fd_sc_hd__decap_3
XFILLER_40_227 VGND VGND VPWR VPWR sky130_fd_sc_hd__fill_2
XFILLER_4_139 VGND VGND VPWR VPWR sky130_fd_sc_hd__fill_1
XFILLER_0_301 VGND VGND VPWR VPWR sky130_fd_sc_hd__decap_3
XFILLER_48_305 VGND VGND VPWR VPWR sky130_fd_sc_hd__decap_3
XFILLER_48_327 VGND VGND VPWR VPWR sky130_fd_sc_hd__decap_3
XTAP_TAPCELL_ROW_3_150 VGND VPWR sky130_fd_sc_hd__tapvpwrvgnd_1
XFILLER_56_360 VGND VGND VPWR VPWR sky130_fd_sc_hd__fill_1
XFILLER_17_50 VGND VGND VPWR VPWR sky130_fd_sc_hd__decap_3
XFILLER_16_224 VGND VGND VPWR VPWR sky130_fd_sc_hd__decap_3
XFILLER_31_216 VGND VGND VPWR VPWR sky130_fd_sc_hd__decap_3
XTAP_TAPCELL_ROW_26_285 VGND VPWR sky130_fd_sc_hd__tapvpwrvgnd_1
X_1490_ _1494_/B _1491_/B VGND VGND VPWR VPWR _1986_/C sky130_fd_sc_hd__nor2_1
X_2111_ _2099_/Y _2109_/X _2110_/Y _2041_/X VGND VGND VPWR VPWR _2131_/A sky130_fd_sc_hd__o211a_1
Xhold1 hold1/A VGND VGND VPWR VPWR hold1/X sky130_fd_sc_hd__dlygate4sd3_1
XFILLER_39_349 VGND VGND VPWR VPWR sky130_fd_sc_hd__decap_3
X_2042_ _1981_/A _1980_/B _1980_/C VGND VGND VPWR VPWR _2042_/X sky130_fd_sc_hd__o21a_1
XTAP_TAPCELL_ROW_17_230 VGND VPWR sky130_fd_sc_hd__tapvpwrvgnd_1
XPHY_EDGE_ROW_8_Right_8 VGND VGND VPWR VPWR sky130_fd_sc_hd__decap_3
XFILLER_22_216 VGND VGND VPWR VPWR sky130_fd_sc_hd__decap_3
XFILLER_22_238 VGND VGND VPWR VPWR sky130_fd_sc_hd__decap_3
X_1826_ _1826_/A _1826_/B VGND VGND VPWR VPWR _1907_/B sky130_fd_sc_hd__xnor2_1
XPHY_EDGE_ROW_29_Left_90 VGND VGND VPWR VPWR sky130_fd_sc_hd__decap_3
X_1757_ _1757_/A _1757_/B VGND VGND VPWR VPWR _1758_/B sky130_fd_sc_hd__or2_1
X_1688_ _1688_/A VGND VGND VPWR VPWR _1696_/A sky130_fd_sc_hd__inv_2
XPHY_EDGE_ROW_39_Right_39 VGND VGND VPWR VPWR sky130_fd_sc_hd__decap_3
XPHY_EDGE_ROW_13_Left_74 VGND VGND VPWR VPWR sky130_fd_sc_hd__decap_3
X_2309_ _2309_/A _2309_/B VGND VGND VPWR VPWR _2312_/A sky130_fd_sc_hd__xor2_2
XFILLER_57_157 VGND VGND VPWR VPWR sky130_fd_sc_hd__decap_3
XFILLER_57_146 VGND VGND VPWR VPWR sky130_fd_sc_hd__decap_3
XTAP_TAPCELL_ROW_0_131 VGND VPWR sky130_fd_sc_hd__tapvpwrvgnd_1
XFILLER_54_15 VGND VGND VPWR VPWR sky130_fd_sc_hd__decap_3
XFILLER_54_59 VGND VGND VPWR VPWR sky130_fd_sc_hd__decap_3
XFILLER_53_352 VGND VGND VPWR VPWR sky130_fd_sc_hd__decap_3
XPHY_EDGE_ROW_48_Right_48 VGND VGND VPWR VPWR sky130_fd_sc_hd__decap_3
XTAP_TAPCELL_ROW_23_266 VGND VPWR sky130_fd_sc_hd__tapvpwrvgnd_1
XPHY_EDGE_ROW_57_Right_57 VGND VGND VPWR VPWR sky130_fd_sc_hd__decap_3
XFILLER_0_131 VGND VGND VPWR VPWR sky130_fd_sc_hd__decap_3
XFILLER_0_153 VGND VGND VPWR VPWR sky130_fd_sc_hd__decap_3
XFILLER_0_175 VGND VGND VPWR VPWR sky130_fd_sc_hd__decap_3
XFILLER_0_197 VGND VGND VPWR VPWR sky130_fd_sc_hd__decap_3
XFILLER_48_135 VGND VGND VPWR VPWR sky130_fd_sc_hd__decap_3
XFILLER_29_360 VGND VGND VPWR VPWR sky130_fd_sc_hd__fill_1
XFILLER_28_82 VGND VGND VPWR VPWR sky130_fd_sc_hd__fill_2
XFILLER_28_60 VGND VGND VPWR VPWR sky130_fd_sc_hd__decap_3
XFILLER_56_190 VGND VGND VPWR VPWR sky130_fd_sc_hd__decap_3
XFILLER_44_341 VGND VGND VPWR VPWR sky130_fd_sc_hd__decap_3
XFILLER_8_220 VGND VGND VPWR VPWR sky130_fd_sc_hd__decap_3
XFILLER_12_293 VGND VGND VPWR VPWR sky130_fd_sc_hd__decap_3
X_2660_ _2660_/A _2660_/B VGND VGND VPWR VPWR _2660_/Y sky130_fd_sc_hd__nor2_1
XFILLER_8_253 VGND VGND VPWR VPWR sky130_fd_sc_hd__fill_2
XFILLER_8_242 VGND VGND VPWR VPWR sky130_fd_sc_hd__decap_3
X_1611_ _1611_/A _1611_/B VGND VGND VPWR VPWR _1612_/B sky130_fd_sc_hd__and2_1
XFILLER_8_286 VGND VGND VPWR VPWR sky130_fd_sc_hd__decap_3
XFILLER_60_91 VGND VGND VPWR VPWR sky130_fd_sc_hd__decap_3
X_2591_ _2591_/A _2591_/B VGND VGND VPWR VPWR _2593_/C sky130_fd_sc_hd__and2_1
X_1542_ _1542_/A _1542_/B _1542_/C VGND VGND VPWR VPWR _1543_/B sky130_fd_sc_hd__nand3_1
XFILLER_5_42 VGND VGND VPWR VPWR sky130_fd_sc_hd__decap_3
X_1473_ _1442_/B _1473_/B _2772_/Q _2754_/A VGND VGND VPWR VPWR _1475_/B sky130_fd_sc_hd__and4b_2
XFILLER_5_75 VGND VGND VPWR VPWR sky130_fd_sc_hd__decap_3
XFILLER_39_146 VGND VGND VPWR VPWR sky130_fd_sc_hd__decap_3
X_2025_ _2160_/A _2095_/B _2027_/B VGND VGND VPWR VPWR wire19/A sky130_fd_sc_hd__nor3_1
XFILLER_50_333 VGND VGND VPWR VPWR sky130_fd_sc_hd__decap_3
XFILLER_24_29 VGND VGND VPWR VPWR sky130_fd_sc_hd__fill_2
X_1809_ _1809_/A _1886_/A _2283_/A VGND VGND VPWR VPWR _1809_/X sky130_fd_sc_hd__or3_1
XFILLER_6_9 VGND VGND VPWR VPWR sky130_fd_sc_hd__decap_3
XFILLER_49_15 VGND VGND VPWR VPWR sky130_fd_sc_hd__decap_3
XFILLER_45_116 VGND VGND VPWR VPWR sky130_fd_sc_hd__decap_3
XFILLER_26_330 VGND VGND VPWR VPWR sky130_fd_sc_hd__decap_3
XFILLER_60_119 VGND VGND VPWR VPWR sky130_fd_sc_hd__decap_3
XFILLER_41_333 VGND VGND VPWR VPWR sky130_fd_sc_hd__decap_3
XFILLER_5_201 VGND VGND VPWR VPWR sky130_fd_sc_hd__decap_3
XFILLER_39_9 VGND VGND VPWR VPWR sky130_fd_sc_hd__decap_3
XTAP_TAPCELL_ROW_59_483 VGND VPWR sky130_fd_sc_hd__tapvpwrvgnd_1
XFILLER_36_127 VGND VGND VPWR VPWR sky130_fd_sc_hd__decap_3
XFILLER_17_330 VGND VGND VPWR VPWR sky130_fd_sc_hd__decap_3
XFILLER_51_119 VGND VGND VPWR VPWR sky130_fd_sc_hd__decap_3
XFILLER_44_182 VGND VGND VPWR VPWR sky130_fd_sc_hd__decap_3
XFILLER_32_344 VGND VGND VPWR VPWR sky130_fd_sc_hd__decap_3
X_2712_ _2712_/A _2719_/B VGND VGND VPWR VPWR _2712_/Y sky130_fd_sc_hd__nor2_1
XTAP_TAPCELL_ROW_42_383 VGND VPWR sky130_fd_sc_hd__tapvpwrvgnd_1
X_2643_ _2643_/A _2719_/B _2643_/C _2646_/C VGND VGND VPWR VPWR _2643_/Y sky130_fd_sc_hd__nand4_1
X_2574_ _2614_/A _2614_/B VGND VGND VPWR VPWR _2610_/B sky130_fd_sc_hd__and2_1
X_1525_ _1587_/A _1886_/B VGND VGND VPWR VPWR _1584_/B sky130_fd_sc_hd__or2_1
XFILLER_59_219 VGND VGND VPWR VPWR sky130_fd_sc_hd__decap_3
X_1456_ _2777_/Q _1456_/B VGND VGND VPWR VPWR _1456_/Y sky130_fd_sc_hd__xnor2_2
X_1387_ _1442_/B _1473_/B VGND VGND VPWR VPWR _1387_/Y sky130_fd_sc_hd__nand2b_1
X_2008_ _2068_/A _2068_/B VGND VGND VPWR VPWR _2008_/Y sky130_fd_sc_hd__nand2b_1
XFILLER_35_160 VGND VGND VPWR VPWR sky130_fd_sc_hd__decap_3
XFILLER_23_322 VGND VGND VPWR VPWR sky130_fd_sc_hd__decap_3
XFILLER_35_193 VGND VGND VPWR VPWR sky130_fd_sc_hd__fill_2
XFILLER_23_333 VGND VGND VPWR VPWR sky130_fd_sc_hd__decap_3
XFILLER_51_27 VGND VGND VPWR VPWR sky130_fd_sc_hd__fill_1
XFILLER_51_49 VGND VGND VPWR VPWR sky130_fd_sc_hd__decap_3
XFILLER_51_38 VGND VGND VPWR VPWR sky130_fd_sc_hd__decap_3
XFILLER_2_204 VGND VGND VPWR VPWR sky130_fd_sc_hd__decap_3
XFILLER_4_6 VGND VGND VPWR VPWR sky130_fd_sc_hd__decap_3
XFILLER_58_274 VGND VGND VPWR VPWR sky130_fd_sc_hd__decap_3
XFILLER_18_127 VGND VGND VPWR VPWR sky130_fd_sc_hd__decap_3
XTAP_TAPCELL_ROW_56_464 VGND VPWR sky130_fd_sc_hd__tapvpwrvgnd_1
XFILLER_33_119 VGND VGND VPWR VPWR sky130_fd_sc_hd__decap_3
XFILLER_26_182 VGND VGND VPWR VPWR sky130_fd_sc_hd__decap_3
XFILLER_26_193 VGND VGND VPWR VPWR sky130_fd_sc_hd__decap_3
XFILLER_14_355 VGND VGND VPWR VPWR sky130_fd_sc_hd__decap_3
XFILLER_25_94 VGND VGND VPWR VPWR sky130_fd_sc_hd__decap_3
XFILLER_41_185 VGND VGND VPWR VPWR sky130_fd_sc_hd__decap_3
XFILLER_41_93 VGND VGND VPWR VPWR sky130_fd_sc_hd__decap_3
XFILLER_41_60 VGND VGND VPWR VPWR sky130_fd_sc_hd__decap_3
XPHY_EDGE_ROW_47_Left_108 VGND VGND VPWR VPWR sky130_fd_sc_hd__decap_3
X_2290_ _2290_/A _2290_/B VGND VGND VPWR VPWR _2297_/A sky130_fd_sc_hd__xor2_1
XFILLER_37_6 VGND VGND VPWR VPWR sky130_fd_sc_hd__decap_3
XFILLER_2_32 VGND VGND VPWR VPWR sky130_fd_sc_hd__decap_3
XFILLER_2_21 VGND VGND VPWR VPWR sky130_fd_sc_hd__decap_3
XFILLER_49_263 VGND VGND VPWR VPWR sky130_fd_sc_hd__decap_3
XFILLER_2_65 VGND VGND VPWR VPWR sky130_fd_sc_hd__decap_3
XPHY_EDGE_ROW_56_Left_117 VGND VGND VPWR VPWR sky130_fd_sc_hd__decap_3
XFILLER_49_296 VGND VGND VPWR VPWR sky130_fd_sc_hd__decap_3
XFILLER_32_141 VGND VGND VPWR VPWR sky130_fd_sc_hd__fill_2
XFILLER_32_130 VGND VGND VPWR VPWR sky130_fd_sc_hd__decap_3
XFILLER_32_152 VGND VGND VPWR VPWR sky130_fd_sc_hd__decap_3
X_2626_ _2626_/A _2626_/B VGND VGND VPWR VPWR _2627_/B sky130_fd_sc_hd__xnor2_1
X_2557_ _2558_/A _2558_/B VGND VGND VPWR VPWR _2557_/X sky130_fd_sc_hd__and2_1
X_1508_ _1502_/B _1501_/X _1524_/B VGND VGND VPWR VPWR _1509_/B sky130_fd_sc_hd__o21bai_1
X_2488_ _2555_/A _2555_/B _2480_/Y VGND VGND VPWR VPWR _2550_/A sky130_fd_sc_hd__a21o_1
X_1439_ _1451_/B _2729_/B _2775_/Q VGND VGND VPWR VPWR _1441_/B sky130_fd_sc_hd__o21ai_4
Xmax_cap17 _1934_/B VGND VGND VPWR VPWR _2012_/A1 sky130_fd_sc_hd__buf_1
XFILLER_46_27 VGND VGND VPWR VPWR sky130_fd_sc_hd__fill_1
XFILLER_55_255 VGND VGND VPWR VPWR sky130_fd_sc_hd__decap_3
XFILLER_55_299 VGND VGND VPWR VPWR sky130_fd_sc_hd__decap_3
XFILLER_15_119 VGND VGND VPWR VPWR sky130_fd_sc_hd__decap_3
XFILLER_11_314 VGND VGND VPWR VPWR sky130_fd_sc_hd__decap_3
XFILLER_23_185 VGND VGND VPWR VPWR sky130_fd_sc_hd__fill_1
XFILLER_7_307 VGND VGND VPWR VPWR sky130_fd_sc_hd__decap_3
XFILLER_11_74 VGND VGND VPWR VPWR sky130_fd_sc_hd__decap_3
XFILLER_11_85 VGND VGND VPWR VPWR sky130_fd_sc_hd__decap_3
XFILLER_11_96 VGND VGND VPWR VPWR sky130_fd_sc_hd__decap_3
XFILLER_46_222 VGND VGND VPWR VPWR sky130_fd_sc_hd__decap_3
XPHY_EDGE_ROW_1_Left_62 VGND VGND VPWR VPWR sky130_fd_sc_hd__decap_3
XFILLER_36_82 VGND VGND VPWR VPWR sky130_fd_sc_hd__fill_2
XFILLER_14_141 VGND VGND VPWR VPWR sky130_fd_sc_hd__decap_3
X_1790_ _1780_/Y _1782_/X _1785_/X _1789_/X VGND VGND VPWR VPWR _1790_/X sky130_fd_sc_hd__o22a_1
Xinput13 uio_in[7] VGND VGND VPWR VPWR _2620_/A sky130_fd_sc_hd__clkbuf_2
XFILLER_6_351 VGND VGND VPWR VPWR sky130_fd_sc_hd__decap_3
X_2411_ _2455_/B _2455_/C _2455_/A VGND VGND VPWR VPWR _2456_/A sky130_fd_sc_hd__o21ai_1
X_2342_ _2341_/B _2341_/C _2341_/A VGND VGND VPWR VPWR _2360_/B sky130_fd_sc_hd__a21boi_1
XFILLER_35_3 VGND VGND VPWR VPWR sky130_fd_sc_hd__decap_3
X_2273_ _2275_/B _2275_/A VGND VGND VPWR VPWR _2273_/X sky130_fd_sc_hd__and2b_1
XFILLER_37_222 VGND VGND VPWR VPWR sky130_fd_sc_hd__fill_2
XFILLER_37_200 VGND VGND VPWR VPWR sky130_fd_sc_hd__decap_3
XFILLER_52_236 VGND VGND VPWR VPWR sky130_fd_sc_hd__fill_1
XFILLER_20_155 VGND VGND VPWR VPWR sky130_fd_sc_hd__decap_3
XFILLER_20_144 VGND VGND VPWR VPWR sky130_fd_sc_hd__fill_1
X_1988_ _1557_/B _1986_/X _1987_/X VGND VGND VPWR VPWR _2033_/B sky130_fd_sc_hd__a21boi_1
X_2609_ _2609_/A _2620_/B VGND VGND VPWR VPWR _2609_/Y sky130_fd_sc_hd__nor2_1
XFILLER_57_15 VGND VGND VPWR VPWR sky130_fd_sc_hd__decap_3
XFILLER_57_48 VGND VGND VPWR VPWR sky130_fd_sc_hd__decap_3
XFILLER_28_200 VGND VGND VPWR VPWR sky130_fd_sc_hd__decap_3
XFILLER_28_233 VGND VGND VPWR VPWR sky130_fd_sc_hd__decap_3
XFILLER_43_225 VGND VGND VPWR VPWR sky130_fd_sc_hd__fill_2
XFILLER_43_214 VGND VGND VPWR VPWR sky130_fd_sc_hd__decap_3
XFILLER_28_288 VGND VGND VPWR VPWR sky130_fd_sc_hd__decap_3
XFILLER_43_247 VGND VGND VPWR VPWR sky130_fd_sc_hd__fill_2
XFILLER_11_111 VGND VGND VPWR VPWR sky130_fd_sc_hd__fill_1
XFILLER_11_144 VGND VGND VPWR VPWR sky130_fd_sc_hd__decap_3
XFILLER_11_166 VGND VGND VPWR VPWR sky130_fd_sc_hd__fill_2
XFILLER_11_199 VGND VGND VPWR VPWR sky130_fd_sc_hd__decap_3
XFILLER_7_137 VGND VGND VPWR VPWR sky130_fd_sc_hd__decap_3
XFILLER_3_343 VGND VGND VPWR VPWR sky130_fd_sc_hd__decap_3
XFILLER_47_70 VGND VGND VPWR VPWR sky130_fd_sc_hd__decap_3
XFILLER_34_225 VGND VGND VPWR VPWR sky130_fd_sc_hd__decap_3
XFILLER_19_299 VGND VGND VPWR VPWR sky130_fd_sc_hd__decap_3
X_1911_ _1982_/A _1982_/B VGND VGND VPWR VPWR _1915_/B sky130_fd_sc_hd__nor2_1
X_1842_ _1465_/A _1995_/B _1841_/A VGND VGND VPWR VPWR _1847_/A sky130_fd_sc_hd__a21oi_1
XFILLER_8_53 VGND VGND VPWR VPWR sky130_fd_sc_hd__decap_3
X_1773_ _1754_/A _1563_/B _1567_/A VGND VGND VPWR VPWR _1774_/B sky130_fd_sc_hd__o21ai_1
XFILLER_8_97 VGND VGND VPWR VPWR sky130_fd_sc_hd__decap_3
XFILLER_6_170 VGND VGND VPWR VPWR sky130_fd_sc_hd__decap_3
X_2325_ _2303_/B _2323_/Y _2322_/Y _2321_/B VGND VGND VPWR VPWR _2326_/C sky130_fd_sc_hd__a211oi_1
XFILLER_57_317 VGND VGND VPWR VPWR sky130_fd_sc_hd__decap_3
X_2256_ _2269_/A _2256_/B VGND VGND VPWR VPWR _2288_/B sky130_fd_sc_hd__nor2_1
X_2187_ _2178_/Y _2180_/Y _2188_/A _2186_/X VGND VGND VPWR VPWR _2188_/B sky130_fd_sc_hd__a211oi_1
XFILLER_25_258 VGND VGND VPWR VPWR sky130_fd_sc_hd__decap_3
XFILLER_25_225 VGND VGND VPWR VPWR sky130_fd_sc_hd__decap_3
XFILLER_40_239 VGND VGND VPWR VPWR sky130_fd_sc_hd__decap_3
XFILLER_4_118 VGND VGND VPWR VPWR sky130_fd_sc_hd__decap_3
XFILLER_0_313 VGND VGND VPWR VPWR sky130_fd_sc_hd__decap_3
XFILLER_0_346 VGND VGND VPWR VPWR sky130_fd_sc_hd__decap_3
XFILLER_48_339 VGND VGND VPWR VPWR sky130_fd_sc_hd__decap_3
XTAP_TAPCELL_ROW_3_151 VGND VPWR sky130_fd_sc_hd__tapvpwrvgnd_1
XFILLER_16_203 VGND VGND VPWR VPWR sky130_fd_sc_hd__decap_3
XFILLER_17_62 VGND VGND VPWR VPWR sky130_fd_sc_hd__decap_3
XTAP_TAPCELL_ROW_26_286 VGND VPWR sky130_fd_sc_hd__tapvpwrvgnd_1
XFILLER_31_228 VGND VGND VPWR VPWR sky130_fd_sc_hd__decap_3
XFILLER_3_151 VGND VGND VPWR VPWR sky130_fd_sc_hd__decap_3
XFILLER_39_306 VGND VGND VPWR VPWR sky130_fd_sc_hd__decap_3
X_2110_ _2041_/A _2041_/B _2041_/C VGND VGND VPWR VPWR _2110_/Y sky130_fd_sc_hd__o21ai_1
XFILLER_58_91 VGND VGND VPWR VPWR sky130_fd_sc_hd__decap_3
XFILLER_58_80 VGND VGND VPWR VPWR sky130_fd_sc_hd__decap_3
X_2041_ _2041_/A _2041_/B _2041_/C VGND VGND VPWR VPWR _2041_/X sky130_fd_sc_hd__or3_2
XFILLER_54_309 VGND VGND VPWR VPWR sky130_fd_sc_hd__decap_3
XTAP_TAPCELL_ROW_17_231 VGND VPWR sky130_fd_sc_hd__tapvpwrvgnd_1
XFILLER_22_206 VGND VGND VPWR VPWR sky130_fd_sc_hd__decap_3
XFILLER_22_228 VGND VGND VPWR VPWR sky130_fd_sc_hd__fill_1
XFILLER_30_250 VGND VGND VPWR VPWR sky130_fd_sc_hd__fill_2
X_1825_ _1826_/B _1826_/A VGND VGND VPWR VPWR _1825_/Y sky130_fd_sc_hd__nand2b_1
X_1756_ _1757_/A _1757_/B VGND VGND VPWR VPWR _1762_/C sky130_fd_sc_hd__nand2_1
X_1687_ _1671_/A _1670_/A _1670_/B VGND VGND VPWR VPWR _1688_/A sky130_fd_sc_hd__a21bo_1
X_2308_ _2363_/B _2363_/A VGND VGND VPWR VPWR _2308_/X sky130_fd_sc_hd__and2b_1
XFILLER_57_125 VGND VGND VPWR VPWR sky130_fd_sc_hd__decap_3
XFILLER_57_169 VGND VGND VPWR VPWR sky130_fd_sc_hd__decap_3
X_2239_ _2247_/B _2247_/A VGND VGND VPWR VPWR _2239_/Y sky130_fd_sc_hd__nand2b_1
XTAP_TAPCELL_ROW_0_132 VGND VPWR sky130_fd_sc_hd__tapvpwrvgnd_1
XFILLER_54_38 VGND VGND VPWR VPWR sky130_fd_sc_hd__decap_3
XFILLER_54_27 VGND VGND VPWR VPWR sky130_fd_sc_hd__fill_1
XFILLER_53_320 VGND VGND VPWR VPWR sky130_fd_sc_hd__decap_3
XTAP_TAPCELL_ROW_23_267 VGND VPWR sky130_fd_sc_hd__tapvpwrvgnd_1
XFILLER_21_272 VGND VGND VPWR VPWR sky130_fd_sc_hd__decap_3
XFILLER_21_250 VGND VGND VPWR VPWR sky130_fd_sc_hd__decap_3
XFILLER_0_187 VGND VGND VPWR VPWR sky130_fd_sc_hd__decap_3
XFILLER_48_103 VGND VGND VPWR VPWR sky130_fd_sc_hd__decap_3
XFILLER_48_147 VGND VGND VPWR VPWR sky130_fd_sc_hd__decap_3
XFILLER_36_309 VGND VGND VPWR VPWR sky130_fd_sc_hd__decap_3
XFILLER_48_169 VGND VGND VPWR VPWR sky130_fd_sc_hd__decap_3
XFILLER_44_353 VGND VGND VPWR VPWR sky130_fd_sc_hd__decap_3
XTAP_TAPCELL_ROW_14_212 VGND VPWR sky130_fd_sc_hd__tapvpwrvgnd_1
XFILLER_44_71 VGND VGND VPWR VPWR sky130_fd_sc_hd__decap_3
XFILLER_12_250 VGND VGND VPWR VPWR sky130_fd_sc_hd__fill_2
XFILLER_12_272 VGND VGND VPWR VPWR sky130_fd_sc_hd__decap_3
XFILLER_8_232 VGND VGND VPWR VPWR sky130_fd_sc_hd__decap_3
X_1610_ _1607_/A _1607_/B _1638_/A VGND VGND VPWR VPWR _1614_/A sky130_fd_sc_hd__a21oi_2
XPHY_EDGE_ROW_30_Left_91 VGND VGND VPWR VPWR sky130_fd_sc_hd__decap_3
XFILLER_60_81 VGND VGND VPWR VPWR sky130_fd_sc_hd__decap_3
X_2590_ _2636_/A _2602_/C _2602_/A VGND VGND VPWR VPWR _2603_/A sky130_fd_sc_hd__o21a_1
XFILLER_5_21 VGND VGND VPWR VPWR sky130_fd_sc_hd__decap_3
X_1541_ _1479_/A _1479_/B _1483_/B VGND VGND VPWR VPWR _1613_/A sky130_fd_sc_hd__o21ai_2
X_1472_ _1442_/B _1473_/B _2772_/Q VGND VGND VPWR VPWR _1494_/B sky130_fd_sc_hd__and3b_2
XFILLER_39_125 VGND VGND VPWR VPWR sky130_fd_sc_hd__decap_3
XFILLER_39_158 VGND VGND VPWR VPWR sky130_fd_sc_hd__decap_3
XFILLER_54_117 VGND VGND VPWR VPWR sky130_fd_sc_hd__decap_3
XFILLER_54_106 VGND VGND VPWR VPWR sky130_fd_sc_hd__decap_3
XFILLER_39_169 VGND VGND VPWR VPWR sky130_fd_sc_hd__decap_3
X_2024_ _2024_/A _2024_/B VGND VGND VPWR VPWR _2027_/B sky130_fd_sc_hd__xnor2_1
XFILLER_47_191 VGND VGND VPWR VPWR sky130_fd_sc_hd__decap_3
XFILLER_50_312 VGND VGND VPWR VPWR sky130_fd_sc_hd__decap_3
XFILLER_50_301 VGND VGND VPWR VPWR sky130_fd_sc_hd__decap_3
XFILLER_50_345 VGND VGND VPWR VPWR sky130_fd_sc_hd__decap_3
XFILLER_10_209 VGND VGND VPWR VPWR sky130_fd_sc_hd__decap_3
XFILLER_40_18 VGND VGND VPWR VPWR sky130_fd_sc_hd__decap_3
X_1808_ _1819_/A _1808_/B VGND VGND VPWR VPWR _1894_/A sky130_fd_sc_hd__nor2_1
XTAP_TAPCELL_ROW_20_248 VGND VPWR sky130_fd_sc_hd__tapvpwrvgnd_1
XFILLER_40_29 VGND VGND VPWR VPWR sky130_fd_sc_hd__fill_2
X_1739_ _1754_/A _1739_/B VGND VGND VPWR VPWR _1742_/A sky130_fd_sc_hd__xor2_1
XFILLER_49_27 VGND VGND VPWR VPWR sky130_fd_sc_hd__decap_3
XFILLER_45_139 VGND VGND VPWR VPWR sky130_fd_sc_hd__decap_3
XFILLER_45_128 VGND VGND VPWR VPWR sky130_fd_sc_hd__decap_3
XFILLER_38_191 VGND VGND VPWR VPWR sky130_fd_sc_hd__decap_3
XFILLER_60_109 VGND VGND VPWR VPWR sky130_fd_sc_hd__decap_3
XFILLER_53_150 VGND VGND VPWR VPWR sky130_fd_sc_hd__decap_3
XFILLER_53_172 VGND VGND VPWR VPWR sky130_fd_sc_hd__decap_3
XFILLER_53_194 VGND VGND VPWR VPWR sky130_fd_sc_hd__decap_3
XFILLER_14_85 VGND VGND VPWR VPWR sky130_fd_sc_hd__fill_2
XFILLER_5_213 VGND VGND VPWR VPWR sky130_fd_sc_hd__decap_3
XFILLER_5_235 VGND VGND VPWR VPWR sky130_fd_sc_hd__decap_3
XFILLER_5_279 VGND VGND VPWR VPWR sky130_fd_sc_hd__fill_1
XFILLER_39_82 VGND VGND VPWR VPWR sky130_fd_sc_hd__fill_2
XFILLER_36_106 VGND VGND VPWR VPWR sky130_fd_sc_hd__decap_3
XTAP_TAPCELL_ROW_59_484 VGND VPWR sky130_fd_sc_hd__tapvpwrvgnd_1
XFILLER_36_139 VGND VGND VPWR VPWR sky130_fd_sc_hd__fill_1
XFILLER_55_70 VGND VGND VPWR VPWR sky130_fd_sc_hd__decap_3
XFILLER_44_150 VGND VGND VPWR VPWR sky130_fd_sc_hd__decap_3
XFILLER_44_161 VGND VGND VPWR VPWR sky130_fd_sc_hd__decap_3
XFILLER_32_312 VGND VGND VPWR VPWR sky130_fd_sc_hd__decap_3
XFILLER_44_194 VGND VGND VPWR VPWR sky130_fd_sc_hd__fill_2
XFILLER_32_356 VGND VGND VPWR VPWR sky130_fd_sc_hd__decap_3
X_2711_ input6/X _2711_/B VGND VGND VPWR VPWR uo_out[5] sky130_fd_sc_hd__xnor2_4
XTAP_TAPCELL_ROW_42_384 VGND VPWR sky130_fd_sc_hd__tapvpwrvgnd_1
X_2642_ _2657_/B _2642_/B _2641_/X VGND VGND VPWR VPWR _2642_/X sky130_fd_sc_hd__or3b_1
X_2573_ _2573_/A _2573_/B VGND VGND VPWR VPWR _2614_/B sky130_fd_sc_hd__nand2_1
X_1524_ _2003_/A _1524_/B VGND VGND VPWR VPWR _1774_/A sky130_fd_sc_hd__xnor2_4
X_1455_ _2761_/A _1456_/B VGND VGND VPWR VPWR _1986_/B sky130_fd_sc_hd__xnor2_2
X_1386_ _1442_/B _1473_/B VGND VGND VPWR VPWR _1489_/B sky130_fd_sc_hd__and2b_4
X_2007_ _2007_/A _2007_/B VGND VGND VPWR VPWR _2068_/B sky130_fd_sc_hd__xnor2_1
XFILLER_35_18 VGND VGND VPWR VPWR sky130_fd_sc_hd__decap_3
XFILLER_50_197 VGND VGND VPWR VPWR sky130_fd_sc_hd__decap_3
XFILLER_2_216 VGND VGND VPWR VPWR sky130_fd_sc_hd__decap_3
XFILLER_58_231 VGND VGND VPWR VPWR sky130_fd_sc_hd__decap_3
XFILLER_58_253 VGND VGND VPWR VPWR sky130_fd_sc_hd__decap_3
XFILLER_58_286 VGND VGND VPWR VPWR sky130_fd_sc_hd__decap_3
XFILLER_18_139 VGND VGND VPWR VPWR sky130_fd_sc_hd__fill_1
XTAP_TAPCELL_ROW_56_465 VGND VPWR sky130_fd_sc_hd__tapvpwrvgnd_1
XFILLER_14_301 VGND VGND VPWR VPWR sky130_fd_sc_hd__decap_3
XFILLER_41_131 VGND VGND VPWR VPWR sky130_fd_sc_hd__decap_3
XFILLER_41_164 VGND VGND VPWR VPWR sky130_fd_sc_hd__decap_3
XFILLER_41_142 VGND VGND VPWR VPWR sky130_fd_sc_hd__decap_3
XFILLER_25_73 VGND VGND VPWR VPWR sky130_fd_sc_hd__decap_3
XFILLER_41_197 VGND VGND VPWR VPWR sky130_fd_sc_hd__decap_3
XFILLER_41_50 VGND VGND VPWR VPWR sky130_fd_sc_hd__decap_3
XFILLER_41_72 VGND VGND VPWR VPWR sky130_fd_sc_hd__decap_3
XFILLER_51_9 VGND VGND VPWR VPWR sky130_fd_sc_hd__decap_3
XFILLER_49_242 VGND VGND VPWR VPWR sky130_fd_sc_hd__decap_3
XFILLER_49_231 VGND VGND VPWR VPWR sky130_fd_sc_hd__decap_3
XFILLER_2_44 VGND VGND VPWR VPWR sky130_fd_sc_hd__decap_3
XFILLER_49_275 VGND VGND VPWR VPWR sky130_fd_sc_hd__decap_3
XFILLER_2_77 VGND VGND VPWR VPWR sky130_fd_sc_hd__fill_1
XTAP_TAPCELL_ROW_47_410 VGND VPWR sky130_fd_sc_hd__tapvpwrvgnd_1
XFILLER_24_109 VGND VGND VPWR VPWR sky130_fd_sc_hd__decap_3
XFILLER_17_150 VGND VGND VPWR VPWR sky130_fd_sc_hd__decap_3
XFILLER_32_120 VGND VGND VPWR VPWR sky130_fd_sc_hd__decap_3
XFILLER_32_164 VGND VGND VPWR VPWR sky130_fd_sc_hd__decap_3
XFILLER_20_304 VGND VGND VPWR VPWR sky130_fd_sc_hd__decap_3
XTAP_TAPCELL_ROW_30_310 VGND VPWR sky130_fd_sc_hd__tapvpwrvgnd_1
XFILLER_32_197 VGND VGND VPWR VPWR sky130_fd_sc_hd__decap_3
XFILLER_9_360 VGND VGND VPWR VPWR sky130_fd_sc_hd__fill_1
X_2625_ _2627_/A _2699_/A _2625_/C VGND VGND VPWR VPWR _2707_/A sky130_fd_sc_hd__or3_1
X_2556_ _2570_/A _2562_/A VGND VGND VPWR VPWR _2558_/B sky130_fd_sc_hd__and2b_1
X_1507_ _1517_/A _1502_/B _1501_/X _1506_/X VGND VGND VPWR VPWR _1524_/B sky130_fd_sc_hd__a31o_2
X_2487_ _2560_/A _2560_/B _2482_/X VGND VGND VPWR VPWR _2555_/B sky130_fd_sc_hd__a21o_1
X_1438_ _2775_/Q _1438_/B _2729_/B VGND VGND VPWR VPWR _1441_/A sky130_fd_sc_hd__or3_4
Xmax_cap18 _2131_/Y VGND VGND VPWR VPWR _2186_/A1 sky130_fd_sc_hd__clkbuf_1
XFILLER_55_234 VGND VGND VPWR VPWR sky130_fd_sc_hd__decap_3
XFILLER_55_223 VGND VGND VPWR VPWR sky130_fd_sc_hd__fill_1
XFILLER_55_267 VGND VGND VPWR VPWR sky130_fd_sc_hd__decap_3
XFILLER_15_109 VGND VGND VPWR VPWR sky130_fd_sc_hd__decap_3
XTAP_TAPCELL_ROW_53_446 VGND VPWR sky130_fd_sc_hd__tapvpwrvgnd_1
XFILLER_23_153 VGND VGND VPWR VPWR sky130_fd_sc_hd__decap_3
XFILLER_11_337 VGND VGND VPWR VPWR sky130_fd_sc_hd__fill_1
XFILLER_46_267 VGND VGND VPWR VPWR sky130_fd_sc_hd__decap_3
XFILLER_46_256 VGND VGND VPWR VPWR sky130_fd_sc_hd__decap_3
XFILLER_46_234 VGND VGND VPWR VPWR sky130_fd_sc_hd__decap_3
XFILLER_36_61 VGND VGND VPWR VPWR sky130_fd_sc_hd__decap_3
XFILLER_14_131 VGND VGND VPWR VPWR sky130_fd_sc_hd__fill_2
XFILLER_14_164 VGND VGND VPWR VPWR sky130_fd_sc_hd__fill_2
XFILLER_14_175 VGND VGND VPWR VPWR sky130_fd_sc_hd__fill_1
XFILLER_14_197 VGND VGND VPWR VPWR sky130_fd_sc_hd__decap_3
XFILLER_52_82 VGND VGND VPWR VPWR sky130_fd_sc_hd__fill_2
XFILLER_52_71 VGND VGND VPWR VPWR sky130_fd_sc_hd__fill_1
X_2410_ _2427_/B _2432_/A _2427_/A VGND VGND VPWR VPWR _2455_/C sky130_fd_sc_hd__a21oi_1
X_2341_ _2341_/A _2341_/B _2341_/C VGND VGND VPWR VPWR _2354_/A sky130_fd_sc_hd__and3_1
X_2272_ _2272_/A _2272_/B VGND VGND VPWR VPWR _2275_/B sky130_fd_sc_hd__nor2_1
XFILLER_28_3 VGND VGND VPWR VPWR sky130_fd_sc_hd__fill_1
XFILLER_52_204 VGND VGND VPWR VPWR sky130_fd_sc_hd__decap_3
XFILLER_52_259 VGND VGND VPWR VPWR sky130_fd_sc_hd__decap_3
XFILLER_60_281 VGND VGND VPWR VPWR sky130_fd_sc_hd__decap_3
XFILLER_20_101 VGND VGND VPWR VPWR sky130_fd_sc_hd__decap_3
X_1987_ _2217_/A _1986_/B _1986_/C _1557_/B VGND VGND VPWR VPWR _1987_/X sky130_fd_sc_hd__a22o_1
XFILLER_20_167 VGND VGND VPWR VPWR sky130_fd_sc_hd__decap_3
X_2608_ _2627_/A _2608_/B VGND VGND VPWR VPWR _2620_/B sky130_fd_sc_hd__or2_1
X_2539_ _2539_/A _2539_/B VGND VGND VPWR VPWR _2554_/A sky130_fd_sc_hd__xor2_2
XFILLER_57_27 VGND VGND VPWR VPWR sky130_fd_sc_hd__decap_3
XFILLER_28_223 VGND VGND VPWR VPWR sky130_fd_sc_hd__decap_3
XFILLER_28_212 VGND VGND VPWR VPWR sky130_fd_sc_hd__decap_3
XFILLER_28_256 VGND VGND VPWR VPWR sky130_fd_sc_hd__decap_3
XFILLER_28_245 VGND VGND VPWR VPWR sky130_fd_sc_hd__fill_2
XFILLER_11_123 VGND VGND VPWR VPWR sky130_fd_sc_hd__decap_3
XFILLER_51_281 VGND VGND VPWR VPWR sky130_fd_sc_hd__decap_3
XFILLER_51_270 VGND VGND VPWR VPWR sky130_fd_sc_hd__decap_3
XFILLER_7_105 VGND VGND VPWR VPWR sky130_fd_sc_hd__decap_3
XFILLER_11_178 VGND VGND VPWR VPWR sky130_fd_sc_hd__decap_3
XFILLER_7_116 VGND VGND VPWR VPWR sky130_fd_sc_hd__decap_3
XFILLER_22_41 VGND VGND VPWR VPWR sky130_fd_sc_hd__decap_3
XFILLER_22_85 VGND VGND VPWR VPWR sky130_fd_sc_hd__fill_2
XFILLER_3_333 VGND VGND VPWR VPWR sky130_fd_sc_hd__decap_3
XFILLER_3_355 VGND VGND VPWR VPWR sky130_fd_sc_hd__decap_3
XFILLER_19_223 VGND VGND VPWR VPWR sky130_fd_sc_hd__fill_1
XFILLER_19_212 VGND VGND VPWR VPWR sky130_fd_sc_hd__fill_2
XFILLER_47_82 VGND VGND VPWR VPWR sky130_fd_sc_hd__decap_3
XFILLER_19_234 VGND VGND VPWR VPWR sky130_fd_sc_hd__decap_3
XFILLER_47_93 VGND VGND VPWR VPWR sky130_fd_sc_hd__fill_2
XFILLER_34_237 VGND VGND VPWR VPWR sky130_fd_sc_hd__decap_3
X_1910_ _1910_/A _1910_/B VGND VGND VPWR VPWR _1982_/B sky130_fd_sc_hd__xnor2_1
X_1841_ _1841_/A _1841_/B VGND VGND VPWR VPWR _1995_/B sky130_fd_sc_hd__nor2_1
XFILLER_8_32 VGND VGND VPWR VPWR sky130_fd_sc_hd__decap_3
XFILLER_8_21 VGND VGND VPWR VPWR sky130_fd_sc_hd__decap_3
XFILLER_8_65 VGND VGND VPWR VPWR sky130_fd_sc_hd__decap_3
X_1772_ _1776_/A _1776_/B _1776_/C VGND VGND VPWR VPWR _1779_/A sky130_fd_sc_hd__a21o_1
X_2324_ _2321_/B _2322_/Y _2323_/Y _2303_/B VGND VGND VPWR VPWR _2326_/B sky130_fd_sc_hd__o211a_1
X_2255_ _2084_/A _2335_/B _2254_/C VGND VGND VPWR VPWR _2256_/B sky130_fd_sc_hd__a21oi_1
XFILLER_57_329 VGND VGND VPWR VPWR sky130_fd_sc_hd__decap_3
X_2186_ _2186_/A1 _2184_/X _2183_/X _2166_/Y VGND VGND VPWR VPWR _2186_/X sky130_fd_sc_hd__o211a_1
XFILLER_27_19 VGND VGND VPWR VPWR sky130_fd_sc_hd__decap_3
XFILLER_25_237 VGND VGND VPWR VPWR sky130_fd_sc_hd__decap_3
XFILLER_43_18 VGND VGND VPWR VPWR sky130_fd_sc_hd__decap_3
XFILLER_33_281 VGND VGND VPWR VPWR sky130_fd_sc_hd__decap_3
XFILLER_48_318 VGND VGND VPWR VPWR sky130_fd_sc_hd__decap_3
XFILLER_56_351 VGND VGND VPWR VPWR sky130_fd_sc_hd__decap_3
XFILLER_16_215 VGND VGND VPWR VPWR sky130_fd_sc_hd__decap_3
XFILLER_31_207 VGND VGND VPWR VPWR sky130_fd_sc_hd__decap_3
XTAP_TAPCELL_ROW_26_287 VGND VPWR sky130_fd_sc_hd__tapvpwrvgnd_1
XFILLER_24_281 VGND VGND VPWR VPWR sky130_fd_sc_hd__fill_1
XFILLER_33_40 VGND VGND VPWR VPWR sky130_fd_sc_hd__fill_1
XFILLER_24_292 VGND VGND VPWR VPWR sky130_fd_sc_hd__decap_3
XFILLER_33_95 VGND VGND VPWR VPWR sky130_fd_sc_hd__decap_3
XFILLER_3_130 VGND VGND VPWR VPWR sky130_fd_sc_hd__decap_3
XFILLER_39_329 VGND VGND VPWR VPWR sky130_fd_sc_hd__decap_3
XFILLER_12_6 VGND VGND VPWR VPWR sky130_fd_sc_hd__decap_3
X_2040_ _2040_/A _2040_/B VGND VGND VPWR VPWR _2041_/C sky130_fd_sc_hd__xnor2_1
XFILLER_47_340 VGND VGND VPWR VPWR sky130_fd_sc_hd__decap_3
XTAP_TAPCELL_ROW_17_232 VGND VPWR sky130_fd_sc_hd__tapvpwrvgnd_1
XFILLER_15_281 VGND VGND VPWR VPWR sky130_fd_sc_hd__decap_3
XFILLER_30_262 VGND VGND VPWR VPWR sky130_fd_sc_hd__decap_3
X_1824_ _1824_/A _1824_/B VGND VGND VPWR VPWR _1826_/B sky130_fd_sc_hd__xnor2_1
XFILLER_30_295 VGND VGND VPWR VPWR sky130_fd_sc_hd__decap_3
X_1755_ _1762_/B _1755_/B VGND VGND VPWR VPWR _1757_/B sky130_fd_sc_hd__and2_1
X_1686_ _1684_/A _1684_/B _1685_/X VGND VGND VPWR VPWR _1698_/A sky130_fd_sc_hd__a21bo_1
XFILLER_38_18 VGND VGND VPWR VPWR sky130_fd_sc_hd__decap_3
X_2307_ _2307_/A _2307_/B VGND VGND VPWR VPWR _2363_/B sky130_fd_sc_hd__xnor2_2
XFILLER_57_104 VGND VGND VPWR VPWR sky130_fd_sc_hd__decap_3
X_2238_ _2238_/A _2238_/B VGND VGND VPWR VPWR _2247_/B sky130_fd_sc_hd__xnor2_1
X_2169_ _2261_/B _2173_/B VGND VGND VPWR VPWR _2175_/A sky130_fd_sc_hd__nand2b_1
XTAP_TAPCELL_ROW_0_133 VGND VPWR sky130_fd_sc_hd__tapvpwrvgnd_1
XTAP_TAPCELL_ROW_0_122 VGND VPWR sky130_fd_sc_hd__tapvpwrvgnd_1
XFILLER_53_332 VGND VGND VPWR VPWR sky130_fd_sc_hd__decap_3
XFILLER_53_343 VGND VGND VPWR VPWR sky130_fd_sc_hd__decap_3
XTAP_TAPCELL_ROW_23_268 VGND VPWR sky130_fd_sc_hd__tapvpwrvgnd_1
XFILLER_21_284 VGND VGND VPWR VPWR sky130_fd_sc_hd__fill_2
XFILLER_0_111 VGND VGND VPWR VPWR sky130_fd_sc_hd__fill_1
XFILLER_0_122 VGND VGND VPWR VPWR sky130_fd_sc_hd__decap_3
XFILLER_0_144 VGND VGND VPWR VPWR sky130_fd_sc_hd__decap_3
XFILLER_0_166 VGND VGND VPWR VPWR sky130_fd_sc_hd__fill_2
XFILLER_48_115 VGND VGND VPWR VPWR sky130_fd_sc_hd__decap_3
XFILLER_29_351 VGND VGND VPWR VPWR sky130_fd_sc_hd__decap_3
XFILLER_28_51 VGND VGND VPWR VPWR sky130_fd_sc_hd__decap_3
XFILLER_44_332 VGND VGND VPWR VPWR sky130_fd_sc_hd__decap_3
XFILLER_44_50 VGND VGND VPWR VPWR sky130_fd_sc_hd__decap_3
XTAP_TAPCELL_ROW_14_213 VGND VPWR sky130_fd_sc_hd__tapvpwrvgnd_1
XFILLER_44_94 VGND VGND VPWR VPWR sky130_fd_sc_hd__fill_1
XFILLER_44_83 VGND VGND VPWR VPWR sky130_fd_sc_hd__fill_1
XFILLER_8_200 VGND VGND VPWR VPWR sky130_fd_sc_hd__decap_3
XFILLER_12_284 VGND VGND VPWR VPWR sky130_fd_sc_hd__decap_3
XFILLER_60_60 VGND VGND VPWR VPWR sky130_fd_sc_hd__decap_3
X_1540_ _1542_/A _1542_/B _1542_/C VGND VGND VPWR VPWR _1546_/B sky130_fd_sc_hd__a21o_1
XFILLER_5_55 VGND VGND VPWR VPWR sky130_fd_sc_hd__fill_1
XFILLER_5_33 VGND VGND VPWR VPWR sky130_fd_sc_hd__decap_3
X_1471_ _2754_/A _1489_/B VGND VGND VPWR VPWR _2674_/A sky130_fd_sc_hd__and2_1
XFILLER_5_66 VGND VGND VPWR VPWR sky130_fd_sc_hd__decap_3
XFILLER_39_137 VGND VGND VPWR VPWR sky130_fd_sc_hd__decap_3
X_2023_ _2160_/A _2095_/B VGND VGND VPWR VPWR _2096_/A sky130_fd_sc_hd__nor2_1
XFILLER_54_129 VGND VGND VPWR VPWR sky130_fd_sc_hd__decap_3
XFILLER_50_324 VGND VGND VPWR VPWR sky130_fd_sc_hd__decap_3
XFILLER_50_357 VGND VGND VPWR VPWR sky130_fd_sc_hd__decap_3
X_1807_ _1807_/A _1807_/B _1807_/C VGND VGND VPWR VPWR _1808_/B sky130_fd_sc_hd__nor3_1
XTAP_TAPCELL_ROW_20_249 VGND VPWR sky130_fd_sc_hd__tapvpwrvgnd_1
X_1738_ _1820_/B _1972_/A _1558_/B VGND VGND VPWR VPWR _1739_/B sky130_fd_sc_hd__a21oi_1
X_1669_ _1813_/A _1669_/B VGND VGND VPWR VPWR _1670_/B sky130_fd_sc_hd__nand2_1
XFILLER_38_170 VGND VGND VPWR VPWR sky130_fd_sc_hd__decap_3
XFILLER_26_321 VGND VGND VPWR VPWR sky130_fd_sc_hd__decap_3
XFILLER_53_162 VGND VGND VPWR VPWR sky130_fd_sc_hd__decap_3
XFILLER_5_225 VGND VGND VPWR VPWR sky130_fd_sc_hd__decap_3
XFILLER_5_247 VGND VGND VPWR VPWR sky130_fd_sc_hd__decap_3
XFILLER_30_63 VGND VGND VPWR VPWR sky130_fd_sc_hd__fill_1
XTAP_TAPCELL_ROW_59_485 VGND VPWR sky130_fd_sc_hd__tapvpwrvgnd_1
XFILLER_55_60 VGND VGND VPWR VPWR sky130_fd_sc_hd__decap_3
XFILLER_32_302 VGND VGND VPWR VPWR sky130_fd_sc_hd__decap_3
XFILLER_32_335 VGND VGND VPWR VPWR sky130_fd_sc_hd__decap_3
X_2710_ _2696_/A _2672_/X _2709_/X VGND VGND VPWR VPWR _2711_/B sky130_fd_sc_hd__a21oi_2
XTAP_TAPCELL_ROW_42_385 VGND VPWR sky130_fd_sc_hd__tapvpwrvgnd_1
X_2641_ _2640_/B _2649_/A _2640_/D _2640_/A VGND VGND VPWR VPWR _2641_/X sky130_fd_sc_hd__a31o_1
X_2572_ _2572_/A _2572_/B VGND VGND VPWR VPWR _2573_/B sky130_fd_sc_hd__nand2_1
X_1523_ _1646_/A _1646_/B VGND VGND VPWR VPWR _1653_/B sky130_fd_sc_hd__and2_1
X_1454_ _1820_/B _2222_/A VGND VGND VPWR VPWR _1535_/A sky130_fd_sc_hd__nor2_1
X_1385_ _2384_/A VGND VGND VPWR VPWR _2613_/A sky130_fd_sc_hd__inv_2
X_2006_ _2007_/A _2007_/B VGND VGND VPWR VPWR _2011_/B sky130_fd_sc_hd__and2b_1
XFILLER_35_151 VGND VGND VPWR VPWR sky130_fd_sc_hd__decap_3
XFILLER_23_302 VGND VGND VPWR VPWR sky130_fd_sc_hd__fill_2
XFILLER_50_121 VGND VGND VPWR VPWR sky130_fd_sc_hd__decap_3
XFILLER_35_184 VGND VGND VPWR VPWR sky130_fd_sc_hd__fill_1
XTAP_TAPCELL_ROW_33_330 VGND VPWR sky130_fd_sc_hd__tapvpwrvgnd_1
XFILLER_51_18 VGND VGND VPWR VPWR sky130_fd_sc_hd__decap_3
XFILLER_50_165 VGND VGND VPWR VPWR sky130_fd_sc_hd__decap_3
XFILLER_2_239 VGND VGND VPWR VPWR sky130_fd_sc_hd__decap_3
XFILLER_58_210 VGND VGND VPWR VPWR sky130_fd_sc_hd__decap_3
XFILLER_58_265 VGND VGND VPWR VPWR sky130_fd_sc_hd__decap_3
XFILLER_58_243 VGND VGND VPWR VPWR sky130_fd_sc_hd__decap_3
XFILLER_58_298 VGND VGND VPWR VPWR sky130_fd_sc_hd__decap_3
XFILLER_18_118 VGND VGND VPWR VPWR sky130_fd_sc_hd__decap_3
XTAP_TAPCELL_ROW_56_466 VGND VPWR sky130_fd_sc_hd__tapvpwrvgnd_1
XFILLER_25_30 VGND VGND VPWR VPWR sky130_fd_sc_hd__decap_3
XFILLER_14_346 VGND VGND VPWR VPWR sky130_fd_sc_hd__decap_3
XFILLER_14_324 VGND VGND VPWR VPWR sky130_fd_sc_hd__decap_3
XFILLER_41_176 VGND VGND VPWR VPWR sky130_fd_sc_hd__decap_3
XFILLER_41_84 VGND VGND VPWR VPWR sky130_fd_sc_hd__decap_3
XFILLER_44_9 VGND VGND VPWR VPWR sky130_fd_sc_hd__decap_3
XFILLER_2_12 VGND VGND VPWR VPWR sky130_fd_sc_hd__decap_3
XFILLER_49_254 VGND VGND VPWR VPWR sky130_fd_sc_hd__decap_3
XFILLER_2_56 VGND VGND VPWR VPWR sky130_fd_sc_hd__decap_3
XTAP_TAPCELL_ROW_47_411 VGND VPWR sky130_fd_sc_hd__tapvpwrvgnd_1
XFILLER_49_287 VGND VGND VPWR VPWR sky130_fd_sc_hd__decap_3
XFILLER_17_195 VGND VGND VPWR VPWR sky130_fd_sc_hd__decap_3
XTAP_TAPCELL_ROW_30_311 VGND VPWR sky130_fd_sc_hd__tapvpwrvgnd_1
X_2624_ _2627_/A _2625_/C VGND VGND VPWR VPWR _2699_/B sky130_fd_sc_hd__nor2_1
X_2555_ _2555_/A _2555_/B VGND VGND VPWR VPWR _2570_/A sky130_fd_sc_hd__xor2_2
X_1506_ _1511_/B _1711_/A _1506_/C VGND VGND VPWR VPWR _1506_/X sky130_fd_sc_hd__and3b_1
X_2486_ _2566_/A _2572_/B _2572_/A VGND VGND VPWR VPWR _2560_/B sky130_fd_sc_hd__o21ba_1
X_1437_ _2754_/A _2772_/Q _2774_/Q VGND VGND VPWR VPWR _2729_/B sky130_fd_sc_hd__and3_2
XFILLER_55_202 VGND VGND VPWR VPWR sky130_fd_sc_hd__fill_2
XFILLER_46_29 VGND VGND VPWR VPWR sky130_fd_sc_hd__decap_3
XFILLER_46_18 VGND VGND VPWR VPWR sky130_fd_sc_hd__decap_3
XFILLER_55_246 VGND VGND VPWR VPWR sky130_fd_sc_hd__decap_3
XFILLER_55_279 VGND VGND VPWR VPWR sky130_fd_sc_hd__fill_1
XTAP_TAPCELL_ROW_53_447 VGND VPWR sky130_fd_sc_hd__tapvpwrvgnd_1
XFILLER_11_305 VGND VGND VPWR VPWR sky130_fd_sc_hd__decap_3
XFILLER_23_132 VGND VGND VPWR VPWR sky130_fd_sc_hd__fill_2
XFILLER_11_327 VGND VGND VPWR VPWR sky130_fd_sc_hd__decap_3
XFILLER_11_65 VGND VGND VPWR VPWR sky130_fd_sc_hd__decap_3
XFILLER_46_213 VGND VGND VPWR VPWR sky130_fd_sc_hd__decap_3
XFILLER_46_246 VGND VGND VPWR VPWR sky130_fd_sc_hd__decap_3
XFILLER_36_73 VGND VGND VPWR VPWR sky130_fd_sc_hd__decap_3
XFILLER_36_40 VGND VGND VPWR VPWR sky130_fd_sc_hd__fill_2
XFILLER_14_110 VGND VGND VPWR VPWR sky130_fd_sc_hd__decap_3
XFILLER_6_331 VGND VGND VPWR VPWR sky130_fd_sc_hd__fill_2
XFILLER_42_6 VGND VGND VPWR VPWR sky130_fd_sc_hd__decap_3
X_2340_ _2338_/A _2338_/B _2338_/C VGND VGND VPWR VPWR _2341_/C sky130_fd_sc_hd__a21o_1
X_2271_ _2272_/A _2271_/B _2271_/C VGND VGND VPWR VPWR _2272_/B sky130_fd_sc_hd__nor3_1
XFILLER_37_279 VGND VGND VPWR VPWR sky130_fd_sc_hd__fill_1
XFILLER_52_249 VGND VGND VPWR VPWR sky130_fd_sc_hd__decap_3
XFILLER_52_227 VGND VGND VPWR VPWR sky130_fd_sc_hd__decap_3
XTAP_TAPCELL_ROW_50_428 VGND VPWR sky130_fd_sc_hd__tapvpwrvgnd_1
XFILLER_60_271 VGND VGND VPWR VPWR sky130_fd_sc_hd__decap_3
X_1986_ _2217_/A _1986_/B _1986_/C VGND VGND VPWR VPWR _1986_/X sky130_fd_sc_hd__and3_1
XFILLER_60_293 VGND VGND VPWR VPWR sky130_fd_sc_hd__decap_3
XFILLER_20_135 VGND VGND VPWR VPWR sky130_fd_sc_hd__decap_3
XFILLER_9_191 VGND VGND VPWR VPWR sky130_fd_sc_hd__decap_3
X_2607_ _2607_/A _2611_/A VGND VGND VPWR VPWR _2608_/B sky130_fd_sc_hd__xnor2_1
X_2538_ _2541_/A _2552_/A _2538_/C VGND VGND VPWR VPWR _2538_/X sky130_fd_sc_hd__and3_1
X_2469_ _2473_/A _2498_/A VGND VGND VPWR VPWR _2496_/A sky130_fd_sc_hd__nor2_1
XFILLER_57_39 VGND VGND VPWR VPWR sky130_fd_sc_hd__decap_3
XFILLER_11_102 VGND VGND VPWR VPWR sky130_fd_sc_hd__decap_3
XFILLER_11_135 VGND VGND VPWR VPWR sky130_fd_sc_hd__decap_3
XFILLER_51_293 VGND VGND VPWR VPWR sky130_fd_sc_hd__decap_3
XFILLER_7_128 VGND VGND VPWR VPWR sky130_fd_sc_hd__decap_3
XFILLER_47_61 VGND VGND VPWR VPWR sky130_fd_sc_hd__decap_3
XFILLER_34_216 VGND VGND VPWR VPWR sky130_fd_sc_hd__decap_3
XFILLER_19_279 VGND VGND VPWR VPWR sky130_fd_sc_hd__fill_1
XFILLER_19_257 VGND VGND VPWR VPWR sky130_fd_sc_hd__decap_3
XFILLER_34_249 VGND VGND VPWR VPWR sky130_fd_sc_hd__decap_3
X_1840_ _1829_/A _1704_/B _2219_/B _2045_/B VGND VGND VPWR VPWR _1841_/B sky130_fd_sc_hd__o22a_1
XFILLER_8_44 VGND VGND VPWR VPWR sky130_fd_sc_hd__fill_1
X_1771_ _1771_/A _1771_/B VGND VGND VPWR VPWR _1776_/C sky130_fd_sc_hd__xnor2_1
XFILLER_8_77 VGND VGND VPWR VPWR sky130_fd_sc_hd__decap_3
XFILLER_10_190 VGND VGND VPWR VPWR sky130_fd_sc_hd__decap_3
XFILLER_6_161 VGND VGND VPWR VPWR sky130_fd_sc_hd__decap_3
XFILLER_6_150 VGND VGND VPWR VPWR sky130_fd_sc_hd__decap_3
XFILLER_40_3 VGND VGND VPWR VPWR sky130_fd_sc_hd__decap_3
X_2323_ _2300_/Y _2301_/X _2295_/B _2297_/B VGND VGND VPWR VPWR _2323_/Y sky130_fd_sc_hd__o211ai_1
XFILLER_57_308 VGND VGND VPWR VPWR sky130_fd_sc_hd__decap_3
X_2254_ _2735_/A _2335_/B _2254_/C VGND VGND VPWR VPWR _2269_/A sky130_fd_sc_hd__and3_1
X_2185_ _2166_/Y _2183_/X _2184_/X _2186_/A1 VGND VGND VPWR VPWR _2188_/A sky130_fd_sc_hd__a211oi_1
XFILLER_25_249 VGND VGND VPWR VPWR sky130_fd_sc_hd__decap_3
XFILLER_25_216 VGND VGND VPWR VPWR sky130_fd_sc_hd__decap_3
XFILLER_33_293 VGND VGND VPWR VPWR sky130_fd_sc_hd__decap_3
X_1969_ _1972_/A _1972_/B VGND VGND VPWR VPWR _2034_/A sky130_fd_sc_hd__nand2_1
XFILLER_0_304 VGND VGND VPWR VPWR sky130_fd_sc_hd__decap_3
XFILLER_0_337 VGND VGND VPWR VPWR sky130_fd_sc_hd__decap_3
XFILLER_56_330 VGND VGND VPWR VPWR sky130_fd_sc_hd__decap_3
XFILLER_17_53 VGND VGND VPWR VPWR sky130_fd_sc_hd__decap_3
XFILLER_16_227 VGND VGND VPWR VPWR sky130_fd_sc_hd__fill_1
XTAP_TAPCELL_ROW_26_288 VGND VPWR sky130_fd_sc_hd__tapvpwrvgnd_1
XFILLER_31_219 VGND VGND VPWR VPWR sky130_fd_sc_hd__decap_3
XFILLER_3_142 VGND VGND VPWR VPWR sky130_fd_sc_hd__decap_3
XFILLER_58_71 VGND VGND VPWR VPWR sky130_fd_sc_hd__decap_3
XFILLER_47_352 VGND VGND VPWR VPWR sky130_fd_sc_hd__decap_3
XTAP_TAPCELL_ROW_17_233 VGND VPWR sky130_fd_sc_hd__tapvpwrvgnd_1
XFILLER_22_219 VGND VGND VPWR VPWR sky130_fd_sc_hd__decap_3
XFILLER_30_230 VGND VGND VPWR VPWR sky130_fd_sc_hd__decap_3
XFILLER_30_241 VGND VGND VPWR VPWR sky130_fd_sc_hd__fill_2
X_1823_ _1899_/A _1970_/A _1822_/Y VGND VGND VPWR VPWR _1826_/A sky130_fd_sc_hd__a21bo_1
XFILLER_30_285 VGND VGND VPWR VPWR sky130_fd_sc_hd__decap_3
X_1754_ _1754_/A _1754_/B VGND VGND VPWR VPWR _1755_/B sky130_fd_sc_hd__nand2_1
X_1685_ _2222_/A _1829_/B VGND VGND VPWR VPWR _1685_/X sky130_fd_sc_hd__or2_1
X_2306_ _2328_/A _2328_/B _2304_/Y VGND VGND VPWR VPWR _2363_/A sky130_fd_sc_hd__a21bo_2
X_2237_ _2237_/A _2237_/B VGND VGND VPWR VPWR _2247_/A sky130_fd_sc_hd__nand2_1
XFILLER_57_149 VGND VGND VPWR VPWR sky130_fd_sc_hd__decap_3
XFILLER_38_352 VGND VGND VPWR VPWR sky130_fd_sc_hd__decap_3
X_2168_ _2168_/A _2168_/B VGND VGND VPWR VPWR _2173_/B sky130_fd_sc_hd__xnor2_1
XTAP_TAPCELL_ROW_0_123 VGND VPWR sky130_fd_sc_hd__tapvpwrvgnd_1
XFILLER_54_29 VGND VGND VPWR VPWR sky130_fd_sc_hd__decap_3
XFILLER_54_18 VGND VGND VPWR VPWR sky130_fd_sc_hd__decap_3
XFILLER_53_311 VGND VGND VPWR VPWR sky130_fd_sc_hd__decap_3
X_2099_ _2108_/A _2108_/B VGND VGND VPWR VPWR _2099_/Y sky130_fd_sc_hd__nor2_1
XFILLER_53_355 VGND VGND VPWR VPWR sky130_fd_sc_hd__decap_3
XTAP_TAPCELL_ROW_23_269 VGND VPWR sky130_fd_sc_hd__tapvpwrvgnd_1
XFILLER_21_241 VGND VGND VPWR VPWR sky130_fd_sc_hd__fill_2
XPHY_EDGE_ROW_17_Right_17 VGND VGND VPWR VPWR sky130_fd_sc_hd__decap_3
XFILLER_0_101 VGND VGND VPWR VPWR sky130_fd_sc_hd__fill_1
XFILLER_0_134 VGND VGND VPWR VPWR sky130_fd_sc_hd__decap_3
XFILLER_0_178 VGND VGND VPWR VPWR sky130_fd_sc_hd__decap_3
XPHY_EDGE_ROW_26_Right_26 VGND VGND VPWR VPWR sky130_fd_sc_hd__decap_3
XFILLER_48_138 VGND VGND VPWR VPWR sky130_fd_sc_hd__fill_2
XFILLER_29_330 VGND VGND VPWR VPWR sky130_fd_sc_hd__decap_3
XFILLER_28_63 VGND VGND VPWR VPWR sky130_fd_sc_hd__decap_3
XFILLER_56_171 VGND VGND VPWR VPWR sky130_fd_sc_hd__decap_3
XFILLER_28_85 VGND VGND VPWR VPWR sky130_fd_sc_hd__decap_3
XFILLER_56_193 VGND VGND VPWR VPWR sky130_fd_sc_hd__decap_3
XFILLER_44_344 VGND VGND VPWR VPWR sky130_fd_sc_hd__decap_3
XFILLER_44_62 VGND VGND VPWR VPWR sky130_fd_sc_hd__decap_3
XTAP_TAPCELL_ROW_14_214 VGND VPWR sky130_fd_sc_hd__tapvpwrvgnd_1
XPHY_EDGE_ROW_35_Right_35 VGND VGND VPWR VPWR sky130_fd_sc_hd__decap_3
XFILLER_8_212 VGND VGND VPWR VPWR sky130_fd_sc_hd__fill_1
XFILLER_12_296 VGND VGND VPWR VPWR sky130_fd_sc_hd__decap_3
XFILLER_8_245 VGND VGND VPWR VPWR sky130_fd_sc_hd__decap_3
XFILLER_8_223 VGND VGND VPWR VPWR sky130_fd_sc_hd__decap_3
XFILLER_60_72 VGND VGND VPWR VPWR sky130_fd_sc_hd__decap_3
XFILLER_60_50 VGND VGND VPWR VPWR sky130_fd_sc_hd__decap_3
XFILLER_8_289 VGND VGND VPWR VPWR sky130_fd_sc_hd__fill_1
XFILLER_60_94 VGND VGND VPWR VPWR sky130_fd_sc_hd__decap_3
XFILLER_5_12 VGND VGND VPWR VPWR sky130_fd_sc_hd__decap_3
XFILLER_5_45 VGND VGND VPWR VPWR sky130_fd_sc_hd__decap_3
X_1470_ _1537_/B _1470_/B VGND VGND VPWR VPWR _1479_/A sky130_fd_sc_hd__nand2_1
XPHY_EDGE_ROW_44_Right_44 VGND VGND VPWR VPWR sky130_fd_sc_hd__decap_3
XFILLER_39_149 VGND VGND VPWR VPWR sky130_fd_sc_hd__decap_3
X_2022_ _2022_/A _2022_/B VGND VGND VPWR VPWR _2095_/B sky130_fd_sc_hd__xor2_2
XPHY_EDGE_ROW_53_Right_53 VGND VGND VPWR VPWR sky130_fd_sc_hd__decap_3
XFILLER_50_336 VGND VGND VPWR VPWR sky130_fd_sc_hd__decap_3
XPHY_EDGE_ROW_17_Left_78 VGND VGND VPWR VPWR sky130_fd_sc_hd__decap_3
X_1806_ _1807_/A _1807_/B _1807_/C VGND VGND VPWR VPWR _1819_/A sky130_fd_sc_hd__o21a_1
X_1737_ _2057_/A _2057_/B VGND VGND VPWR VPWR _2059_/A sky130_fd_sc_hd__nand2_1
X_1668_ _1813_/A _1669_/B VGND VGND VPWR VPWR _1670_/A sky130_fd_sc_hd__or2_1
XFILLER_49_18 VGND VGND VPWR VPWR sky130_fd_sc_hd__decap_3
X_1599_ _1809_/A _2201_/B VGND VGND VPWR VPWR _1622_/B sky130_fd_sc_hd__nor2_1
XFILLER_45_119 VGND VGND VPWR VPWR sky130_fd_sc_hd__decap_3
XFILLER_38_160 VGND VGND VPWR VPWR sky130_fd_sc_hd__decap_3
XFILLER_53_130 VGND VGND VPWR VPWR sky130_fd_sc_hd__fill_1
XFILLER_26_333 VGND VGND VPWR VPWR sky130_fd_sc_hd__decap_3
XFILLER_41_303 VGND VGND VPWR VPWR sky130_fd_sc_hd__decap_3
XFILLER_41_358 VGND VGND VPWR VPWR sky130_fd_sc_hd__decap_3
XFILLER_5_204 VGND VGND VPWR VPWR sky130_fd_sc_hd__decap_3
XFILLER_30_42 VGND VGND VPWR VPWR sky130_fd_sc_hd__decap_3
XFILLER_39_73 VGND VGND VPWR VPWR sky130_fd_sc_hd__decap_3
XTAP_TAPCELL_ROW_59_486 VGND VPWR sky130_fd_sc_hd__tapvpwrvgnd_1
XFILLER_17_311 VGND VGND VPWR VPWR sky130_fd_sc_hd__decap_3
XFILLER_44_130 VGND VGND VPWR VPWR sky130_fd_sc_hd__decap_3
XFILLER_29_182 VGND VGND VPWR VPWR sky130_fd_sc_hd__fill_2
XFILLER_17_333 VGND VGND VPWR VPWR sky130_fd_sc_hd__decap_3
XFILLER_55_83 VGND VGND VPWR VPWR sky130_fd_sc_hd__decap_3
XFILLER_44_185 VGND VGND VPWR VPWR sky130_fd_sc_hd__decap_3
XFILLER_32_347 VGND VGND VPWR VPWR sky130_fd_sc_hd__fill_2
X_2640_ _2640_/A _2640_/B _2649_/A _2640_/D VGND VGND VPWR VPWR _2642_/B sky130_fd_sc_hd__and4_1
X_2571_ _2571_/A _2571_/B VGND VGND VPWR VPWR _2610_/A sky130_fd_sc_hd__or2_1
X_1522_ _1653_/A _1522_/B VGND VGND VPWR VPWR _1646_/B sky130_fd_sc_hd__nor2_1
X_1453_ _1444_/Y _1451_/X _1450_/X VGND VGND VPWR VPWR _1557_/B sky130_fd_sc_hd__o21a_2
X_1384_ _2620_/A VGND VGND VPWR VPWR _2609_/A sky130_fd_sc_hd__inv_2
X_2005_ _2005_/A _2005_/B VGND VGND VPWR VPWR _2007_/B sky130_fd_sc_hd__xnor2_1
XFILLER_35_163 VGND VGND VPWR VPWR sky130_fd_sc_hd__decap_3
XTAP_TAPCELL_ROW_33_331 VGND VPWR sky130_fd_sc_hd__tapvpwrvgnd_1
X_2769_ clkload0/A _2769_/D fanout47/X VGND VGND VPWR VPWR hold1/A sky130_fd_sc_hd__dfrtp_1
XFILLER_2_207 VGND VGND VPWR VPWR sky130_fd_sc_hd__decap_3
XFILLER_4_9 VGND VGND VPWR VPWR sky130_fd_sc_hd__decap_3
XFILLER_58_222 VGND VGND VPWR VPWR sky130_fd_sc_hd__decap_3
XFILLER_58_200 VGND VGND VPWR VPWR sky130_fd_sc_hd__decap_3
XFILLER_58_277 VGND VGND VPWR VPWR sky130_fd_sc_hd__decap_3
XTAP_TAPCELL_ROW_56_467 VGND VPWR sky130_fd_sc_hd__tapvpwrvgnd_1
XFILLER_26_141 VGND VGND VPWR VPWR sky130_fd_sc_hd__decap_3
XFILLER_41_122 VGND VGND VPWR VPWR sky130_fd_sc_hd__decap_3
XFILLER_41_111 VGND VGND VPWR VPWR sky130_fd_sc_hd__fill_1
XFILLER_25_42 VGND VGND VPWR VPWR sky130_fd_sc_hd__decap_3
XFILLER_25_97 VGND VGND VPWR VPWR sky130_fd_sc_hd__decap_3
XFILLER_41_188 VGND VGND VPWR VPWR sky130_fd_sc_hd__decap_3
XFILLER_41_63 VGND VGND VPWR VPWR sky130_fd_sc_hd__decap_3
XFILLER_41_96 VGND VGND VPWR VPWR sky130_fd_sc_hd__decap_3
XFILLER_37_9 VGND VGND VPWR VPWR sky130_fd_sc_hd__decap_3
XFILLER_49_222 VGND VGND VPWR VPWR sky130_fd_sc_hd__fill_2
XFILLER_49_200 VGND VGND VPWR VPWR sky130_fd_sc_hd__decap_3
XFILLER_2_35 VGND VGND VPWR VPWR sky130_fd_sc_hd__decap_3
XFILLER_2_24 VGND VGND VPWR VPWR sky130_fd_sc_hd__decap_3
XFILLER_49_266 VGND VGND VPWR VPWR sky130_fd_sc_hd__decap_3
XFILLER_2_68 VGND VGND VPWR VPWR sky130_fd_sc_hd__fill_2
XTAP_TAPCELL_ROW_47_412 VGND VPWR sky130_fd_sc_hd__tapvpwrvgnd_1
XFILLER_49_299 VGND VGND VPWR VPWR sky130_fd_sc_hd__decap_3
XFILLER_17_141 VGND VGND VPWR VPWR sky130_fd_sc_hd__decap_3
XFILLER_32_111 VGND VGND VPWR VPWR sky130_fd_sc_hd__decap_3
XFILLER_32_155 VGND VGND VPWR VPWR sky130_fd_sc_hd__decap_3
XFILLER_32_133 VGND VGND VPWR VPWR sky130_fd_sc_hd__decap_3
XTAP_TAPCELL_ROW_30_312 VGND VPWR sky130_fd_sc_hd__tapvpwrvgnd_1
XFILLER_20_328 VGND VGND VPWR VPWR sky130_fd_sc_hd__decap_3
X_2623_ _2623_/A _2623_/B VGND VGND VPWR VPWR _2625_/C sky130_fd_sc_hd__xor2_1
X_2554_ _2554_/A _2564_/A VGND VGND VPWR VPWR _2558_/A sky130_fd_sc_hd__xor2_1
X_1505_ _1898_/A _2206_/A _2057_/A VGND VGND VPWR VPWR _2000_/A sky130_fd_sc_hd__a21oi_4
X_2485_ _2485_/A _2485_/B VGND VGND VPWR VPWR _2572_/B sky130_fd_sc_hd__xnor2_1
X_1436_ _1671_/A _1635_/B _1435_/A VGND VGND VPWR VPWR _1484_/A sky130_fd_sc_hd__a21o_1
XFILLER_55_225 VGND VGND VPWR VPWR sky130_fd_sc_hd__decap_3
XFILLER_55_258 VGND VGND VPWR VPWR sky130_fd_sc_hd__decap_3
XPHY_EDGE_ROW_43_Left_104 VGND VGND VPWR VPWR sky130_fd_sc_hd__decap_3
XTAP_TAPCELL_ROW_53_448 VGND VPWR sky130_fd_sc_hd__tapvpwrvgnd_1
XFILLER_23_111 VGND VGND VPWR VPWR sky130_fd_sc_hd__fill_1
XFILLER_11_317 VGND VGND VPWR VPWR sky130_fd_sc_hd__decap_3
XPHY_EDGE_ROW_52_Left_113 VGND VGND VPWR VPWR sky130_fd_sc_hd__decap_3
XFILLER_11_77 VGND VGND VPWR VPWR sky130_fd_sc_hd__fill_2
XFILLER_11_88 VGND VGND VPWR VPWR sky130_fd_sc_hd__fill_1
XFILLER_11_99 VGND VGND VPWR VPWR sky130_fd_sc_hd__decap_3
XFILLER_2_6 VGND VGND VPWR VPWR sky130_fd_sc_hd__decap_3
XFILLER_46_225 VGND VGND VPWR VPWR sky130_fd_sc_hd__decap_3
XFILLER_36_52 VGND VGND VPWR VPWR sky130_fd_sc_hd__decap_3
XFILLER_14_122 VGND VGND VPWR VPWR sky130_fd_sc_hd__decap_3
XFILLER_36_85 VGND VGND VPWR VPWR sky130_fd_sc_hd__decap_3
XFILLER_14_144 VGND VGND VPWR VPWR sky130_fd_sc_hd__decap_3
XFILLER_54_291 VGND VGND VPWR VPWR sky130_fd_sc_hd__decap_3
XFILLER_52_51 VGND VGND VPWR VPWR sky130_fd_sc_hd__decap_3
XFILLER_52_95 VGND VGND VPWR VPWR sky130_fd_sc_hd__decap_3
XFILLER_6_354 VGND VGND VPWR VPWR sky130_fd_sc_hd__decap_3
X_2270_ _2293_/A _2270_/B VGND VGND VPWR VPWR _2271_/C sky130_fd_sc_hd__xnor2_1
XFILLER_35_6 VGND VGND VPWR VPWR sky130_fd_sc_hd__decap_3
XTAP_TAPCELL_ROW_50_429 VGND VPWR sky130_fd_sc_hd__tapvpwrvgnd_1
X_1985_ _2222_/A _1985_/B VGND VGND VPWR VPWR _2050_/A sky130_fd_sc_hd__nor2_1
XFILLER_20_158 VGND VGND VPWR VPWR sky130_fd_sc_hd__decap_3
X_2606_ _2627_/A _2606_/B VGND VGND VPWR VPWR _2691_/A sky130_fd_sc_hd__or2_1
X_2537_ _2537_/A _2543_/A VGND VGND VPWR VPWR _2538_/C sky130_fd_sc_hd__xnor2_1
X_2468_ _2468_/A _2468_/B VGND VGND VPWR VPWR _2468_/X sky130_fd_sc_hd__or2_1
X_1419_ _1438_/B _1416_/D _2767_/Q VGND VGND VPWR VPWR _1421_/B sky130_fd_sc_hd__o21ai_2
XFILLER_57_18 VGND VGND VPWR VPWR sky130_fd_sc_hd__decap_3
X_2399_ input8/X _2483_/A VGND VGND VPWR VPWR _2434_/B sky130_fd_sc_hd__nand2_1
XFILLER_28_203 VGND VGND VPWR VPWR sky130_fd_sc_hd__decap_3
XFILLER_28_236 VGND VGND VPWR VPWR sky130_fd_sc_hd__decap_3
XFILLER_43_206 VGND VGND VPWR VPWR sky130_fd_sc_hd__fill_2
XFILLER_43_217 VGND VGND VPWR VPWR sky130_fd_sc_hd__decap_3
XFILLER_36_280 VGND VGND VPWR VPWR sky130_fd_sc_hd__fill_2
XFILLER_36_291 VGND VGND VPWR VPWR sky130_fd_sc_hd__decap_3
XFILLER_51_261 VGND VGND VPWR VPWR sky130_fd_sc_hd__decap_3
XFILLER_51_250 VGND VGND VPWR VPWR sky130_fd_sc_hd__fill_2
XFILLER_11_147 VGND VGND VPWR VPWR sky130_fd_sc_hd__decap_3
XFILLER_11_169 VGND VGND VPWR VPWR sky130_fd_sc_hd__decap_3
XFILLER_22_54 VGND VGND VPWR VPWR sky130_fd_sc_hd__decap_3
XFILLER_3_302 VGND VGND VPWR VPWR sky130_fd_sc_hd__decap_3
XPHY_EDGE_ROW_5_Left_66 VGND VGND VPWR VPWR sky130_fd_sc_hd__decap_3
XFILLER_3_313 VGND VGND VPWR VPWR sky130_fd_sc_hd__decap_3
XFILLER_0_3 VGND VGND VPWR VPWR sky130_fd_sc_hd__decap_3
XFILLER_3_346 VGND VGND VPWR VPWR sky130_fd_sc_hd__decap_3
XFILLER_47_73 VGND VGND VPWR VPWR sky130_fd_sc_hd__decap_3
XFILLER_19_247 VGND VGND VPWR VPWR sky130_fd_sc_hd__decap_3
XFILLER_19_225 VGND VGND VPWR VPWR sky130_fd_sc_hd__decap_3
XFILLER_34_228 VGND VGND VPWR VPWR sky130_fd_sc_hd__decap_3
XFILLER_42_261 VGND VGND VPWR VPWR sky130_fd_sc_hd__decap_3
XFILLER_8_12 VGND VGND VPWR VPWR sky130_fd_sc_hd__decap_3
XFILLER_42_294 VGND VGND VPWR VPWR sky130_fd_sc_hd__fill_1
X_1770_ _1770_/A _1770_/B VGND VGND VPWR VPWR _1782_/B sky130_fd_sc_hd__or2_1
XFILLER_8_56 VGND VGND VPWR VPWR sky130_fd_sc_hd__decap_3
XFILLER_6_173 VGND VGND VPWR VPWR sky130_fd_sc_hd__decap_3
X_2322_ _2338_/A VGND VGND VPWR VPWR _2322_/Y sky130_fd_sc_hd__inv_2
X_2253_ _2253_/A _2263_/A VGND VGND VPWR VPWR _2254_/C sky130_fd_sc_hd__xnor2_1
X_2184_ _2131_/A _2131_/B _2131_/C VGND VGND VPWR VPWR _2184_/X sky130_fd_sc_hd__o21a_1
XFILLER_25_228 VGND VGND VPWR VPWR sky130_fd_sc_hd__decap_3
XFILLER_18_291 VGND VGND VPWR VPWR sky130_fd_sc_hd__fill_1
X_1968_ _1968_/A _1968_/B VGND VGND VPWR VPWR _2037_/A sky130_fd_sc_hd__xnor2_2
X_1899_ _1899_/A _1899_/B VGND VGND VPWR VPWR _1901_/B sky130_fd_sc_hd__nor2_1
XFILLER_0_316 VGND VGND VPWR VPWR sky130_fd_sc_hd__decap_3
XFILLER_0_327 VGND VGND VPWR VPWR sky130_fd_sc_hd__decap_3
XFILLER_0_349 VGND VGND VPWR VPWR sky130_fd_sc_hd__decap_3
XFILLER_48_309 VGND VGND VPWR VPWR sky130_fd_sc_hd__decap_3
XFILLER_56_342 VGND VGND VPWR VPWR sky130_fd_sc_hd__decap_3
XFILLER_17_21 VGND VGND VPWR VPWR sky130_fd_sc_hd__fill_1
XFILLER_17_65 VGND VGND VPWR VPWR sky130_fd_sc_hd__fill_2
XFILLER_17_98 VGND VGND VPWR VPWR sky130_fd_sc_hd__decap_3
XFILLER_24_272 VGND VGND VPWR VPWR sky130_fd_sc_hd__decap_3
XTAP_TAPCELL_ROW_26_289 VGND VPWR sky130_fd_sc_hd__tapvpwrvgnd_1
XFILLER_3_110 VGND VGND VPWR VPWR sky130_fd_sc_hd__fill_2
XFILLER_3_187 VGND VGND VPWR VPWR sky130_fd_sc_hd__decap_3
XFILLER_58_83 VGND VGND VPWR VPWR sky130_fd_sc_hd__fill_1
XFILLER_58_50 VGND VGND VPWR VPWR sky130_fd_sc_hd__decap_3
XFILLER_39_309 VGND VGND VPWR VPWR sky130_fd_sc_hd__decap_3
XFILLER_58_94 VGND VGND VPWR VPWR sky130_fd_sc_hd__decap_3
XFILLER_47_320 VGND VGND VPWR VPWR sky130_fd_sc_hd__decap_3
XTAP_TAPCELL_ROW_17_234 VGND VPWR sky130_fd_sc_hd__tapvpwrvgnd_1
XFILLER_22_209 VGND VGND VPWR VPWR sky130_fd_sc_hd__fill_1
X_1822_ _1995_/A _1897_/B VGND VGND VPWR VPWR _1822_/Y sky130_fd_sc_hd__nand2_1
XFILLER_30_253 VGND VGND VPWR VPWR sky130_fd_sc_hd__decap_3
X_1753_ _1754_/A _1754_/B VGND VGND VPWR VPWR _1762_/B sky130_fd_sc_hd__or2_1
X_1684_ _1684_/A _1684_/B VGND VGND VPWR VPWR _1829_/B sky130_fd_sc_hd__xnor2_1
X_2305_ _2305_/A _2305_/B VGND VGND VPWR VPWR _2328_/B sky130_fd_sc_hd__xnor2_2
X_2236_ _2238_/A _2238_/B VGND VGND VPWR VPWR _2236_/X sky130_fd_sc_hd__or2_1
XFILLER_57_128 VGND VGND VPWR VPWR sky130_fd_sc_hd__decap_3
X_2167_ _2773_/Q _2336_/A VGND VGND VPWR VPWR _2261_/B sky130_fd_sc_hd__nand2_1
XTAP_TAPCELL_ROW_0_124 VGND VPWR sky130_fd_sc_hd__tapvpwrvgnd_1
XFILLER_53_323 VGND VGND VPWR VPWR sky130_fd_sc_hd__decap_3
X_2098_ _2098_/A _2098_/B VGND VGND VPWR VPWR _2108_/B sky130_fd_sc_hd__xnor2_1
XFILLER_21_253 VGND VGND VPWR VPWR sky130_fd_sc_hd__decap_3
XFILLER_21_275 VGND VGND VPWR VPWR sky130_fd_sc_hd__decap_3
XFILLER_0_113 VGND VGND VPWR VPWR sky130_fd_sc_hd__decap_3
XFILLER_48_106 VGND VGND VPWR VPWR sky130_fd_sc_hd__decap_3
XFILLER_56_150 VGND VGND VPWR VPWR sky130_fd_sc_hd__fill_1
XFILLER_44_356 VGND VGND VPWR VPWR sky130_fd_sc_hd__decap_3
XFILLER_44_41 VGND VGND VPWR VPWR sky130_fd_sc_hd__decap_3
XTAP_TAPCELL_ROW_14_215 VGND VPWR sky130_fd_sc_hd__tapvpwrvgnd_1
XFILLER_44_85 VGND VGND VPWR VPWR sky130_fd_sc_hd__decap_3
XFILLER_44_74 VGND VGND VPWR VPWR sky130_fd_sc_hd__decap_3
XFILLER_12_231 VGND VGND VPWR VPWR sky130_fd_sc_hd__decap_3
XFILLER_12_275 VGND VGND VPWR VPWR sky130_fd_sc_hd__decap_3
XFILLER_8_268 VGND VGND VPWR VPWR sky130_fd_sc_hd__decap_3
XFILLER_5_24 VGND VGND VPWR VPWR sky130_fd_sc_hd__decap_3
XFILLER_5_57 VGND VGND VPWR VPWR sky130_fd_sc_hd__decap_3
XFILLER_39_128 VGND VGND VPWR VPWR sky130_fd_sc_hd__decap_3
X_2021_ _2021_/A _2021_/B _2022_/A VGND VGND VPWR VPWR _2021_/Y sky130_fd_sc_hd__nand3_1
XFILLER_54_109 VGND VGND VPWR VPWR sky130_fd_sc_hd__decap_3
XFILLER_47_194 VGND VGND VPWR VPWR sky130_fd_sc_hd__decap_3
XFILLER_50_315 VGND VGND VPWR VPWR sky130_fd_sc_hd__decap_3
XFILLER_50_304 VGND VGND VPWR VPWR sky130_fd_sc_hd__decap_3
XFILLER_50_348 VGND VGND VPWR VPWR sky130_fd_sc_hd__decap_3
X_1805_ _1664_/S _1663_/A _1805_/S VGND VGND VPWR VPWR _1807_/C sky130_fd_sc_hd__mux2_1
X_1736_ _1999_/A _1736_/B VGND VGND VPWR VPWR _2057_/B sky130_fd_sc_hd__xnor2_1
X_1667_ _1817_/A VGND VGND VPWR VPWR _1672_/A sky130_fd_sc_hd__inv_2
X_1598_ _1597_/A _2199_/B _1656_/A VGND VGND VPWR VPWR _2201_/B sky130_fd_sc_hd__mux2_1
X_2219_ _2336_/A _2219_/B VGND VGND VPWR VPWR _2221_/B sky130_fd_sc_hd__nor2_1
XFILLER_26_312 VGND VGND VPWR VPWR sky130_fd_sc_hd__decap_3
XFILLER_26_301 VGND VGND VPWR VPWR sky130_fd_sc_hd__decap_3
XFILLER_38_194 VGND VGND VPWR VPWR sky130_fd_sc_hd__fill_2
XFILLER_26_356 VGND VGND VPWR VPWR sky130_fd_sc_hd__decap_3
XFILLER_53_175 VGND VGND VPWR VPWR sky130_fd_sc_hd__decap_3
XFILLER_53_197 VGND VGND VPWR VPWR sky130_fd_sc_hd__decap_3
XFILLER_14_66 VGND VGND VPWR VPWR sky130_fd_sc_hd__decap_3
XFILLER_5_216 VGND VGND VPWR VPWR sky130_fd_sc_hd__decap_3
XFILLER_30_21 VGND VGND VPWR VPWR sky130_fd_sc_hd__decap_3
XFILLER_30_98 VGND VGND VPWR VPWR sky130_fd_sc_hd__decap_3
XTAP_TAPCELL_ROW_59_487 VGND VPWR sky130_fd_sc_hd__tapvpwrvgnd_1
XPHY_EDGE_ROW_34_Left_95 VGND VGND VPWR VPWR sky130_fd_sc_hd__decap_3
XFILLER_36_109 VGND VGND VPWR VPWR sky130_fd_sc_hd__decap_3
XFILLER_29_172 VGND VGND VPWR VPWR sky130_fd_sc_hd__fill_2
XFILLER_29_161 VGND VGND VPWR VPWR sky130_fd_sc_hd__decap_3
XFILLER_55_73 VGND VGND VPWR VPWR sky130_fd_sc_hd__decap_3
XFILLER_44_164 VGND VGND VPWR VPWR sky130_fd_sc_hd__fill_2
XFILLER_44_153 VGND VGND VPWR VPWR sky130_fd_sc_hd__fill_1
XFILLER_44_197 VGND VGND VPWR VPWR sky130_fd_sc_hd__decap_3
XFILLER_32_326 VGND VGND VPWR VPWR sky130_fd_sc_hd__decap_3
XFILLER_32_315 VGND VGND VPWR VPWR sky130_fd_sc_hd__decap_3
XFILLER_32_359 VGND VGND VPWR VPWR sky130_fd_sc_hd__fill_2
X_2570_ _2570_/A _2570_/B VGND VGND VPWR VPWR _2571_/B sky130_fd_sc_hd__and2_1
X_1521_ _1521_/A _1642_/A _1521_/C VGND VGND VPWR VPWR _1522_/B sky130_fd_sc_hd__nor3_1
X_1452_ _1444_/Y _1451_/X _1450_/X VGND VGND VPWR VPWR _1829_/A sky130_fd_sc_hd__o21ai_2
X_1383_ _2777_/Q VGND VGND VPWR VPWR _2761_/A sky130_fd_sc_hd__inv_2
X_2004_ _2005_/A _2005_/B VGND VGND VPWR VPWR _2011_/A sky130_fd_sc_hd__and2b_1
XFILLER_35_131 VGND VGND VPWR VPWR sky130_fd_sc_hd__decap_3
XFILLER_35_142 VGND VGND VPWR VPWR sky130_fd_sc_hd__decap_3
XFILLER_35_175 VGND VGND VPWR VPWR sky130_fd_sc_hd__decap_3
XFILLER_23_337 VGND VGND VPWR VPWR sky130_fd_sc_hd__fill_2
X_2768_ clkload0/A _2768_/D fanout47/X VGND VGND VPWR VPWR _2768_/Q sky130_fd_sc_hd__dfrtp_2
X_1719_ _1720_/B _1720_/A VGND VGND VPWR VPWR _1719_/X sky130_fd_sc_hd__and2b_1
X_2699_ _2699_/A _2699_/B VGND VGND VPWR VPWR _2699_/Y sky130_fd_sc_hd__xnor2_1
XFILLER_2_219 VGND VGND VPWR VPWR sky130_fd_sc_hd__decap_3
XFILLER_58_256 VGND VGND VPWR VPWR sky130_fd_sc_hd__decap_3
XFILLER_58_234 VGND VGND VPWR VPWR sky130_fd_sc_hd__decap_3
XFILLER_58_289 VGND VGND VPWR VPWR sky130_fd_sc_hd__decap_3
XFILLER_26_120 VGND VGND VPWR VPWR sky130_fd_sc_hd__decap_3
XTAP_TAPCELL_ROW_56_468 VGND VPWR sky130_fd_sc_hd__tapvpwrvgnd_1
XFILLER_25_21 VGND VGND VPWR VPWR sky130_fd_sc_hd__decap_3
XFILLER_14_304 VGND VGND VPWR VPWR sky130_fd_sc_hd__decap_3
XFILLER_26_197 VGND VGND VPWR VPWR sky130_fd_sc_hd__decap_3
XFILLER_26_175 VGND VGND VPWR VPWR sky130_fd_sc_hd__decap_3
XFILLER_41_145 VGND VGND VPWR VPWR sky130_fd_sc_hd__decap_3
XFILLER_41_134 VGND VGND VPWR VPWR sky130_fd_sc_hd__decap_3
XFILLER_25_76 VGND VGND VPWR VPWR sky130_fd_sc_hd__fill_1
XFILLER_41_167 VGND VGND VPWR VPWR sky130_fd_sc_hd__fill_1
XFILLER_41_75 VGND VGND VPWR VPWR sky130_fd_sc_hd__decap_3
XFILLER_41_53 VGND VGND VPWR VPWR sky130_fd_sc_hd__decap_3
XFILLER_49_212 VGND VGND VPWR VPWR sky130_fd_sc_hd__fill_1
XFILLER_49_245 VGND VGND VPWR VPWR sky130_fd_sc_hd__fill_1
XFILLER_49_234 VGND VGND VPWR VPWR sky130_fd_sc_hd__decap_3
XFILLER_2_47 VGND VGND VPWR VPWR sky130_fd_sc_hd__decap_3
XTAP_TAPCELL_ROW_47_413 VGND VPWR sky130_fd_sc_hd__tapvpwrvgnd_1
XFILLER_49_278 VGND VGND VPWR VPWR sky130_fd_sc_hd__fill_2
XFILLER_17_153 VGND VGND VPWR VPWR sky130_fd_sc_hd__decap_3
XFILLER_32_123 VGND VGND VPWR VPWR sky130_fd_sc_hd__fill_1
XFILLER_32_167 VGND VGND VPWR VPWR sky130_fd_sc_hd__decap_3
XFILLER_20_307 VGND VGND VPWR VPWR sky130_fd_sc_hd__fill_1
XTAP_TAPCELL_ROW_30_313 VGND VPWR sky130_fd_sc_hd__tapvpwrvgnd_1
X_2622_ _2691_/A _2691_/B VGND VGND VPWR VPWR _2699_/A sky130_fd_sc_hd__or2_1
X_2553_ _2580_/A _2580_/B VGND VGND VPWR VPWR _2553_/Y sky130_fd_sc_hd__nor2_1
X_1504_ _1898_/A _2206_/A _2057_/A VGND VGND VPWR VPWR _2003_/A sky130_fd_sc_hd__a21o_2
X_2484_ _2484_/A _2484_/B VGND VGND VPWR VPWR _2572_/A sky130_fd_sc_hd__xnor2_1
X_1435_ _1435_/A _1435_/B VGND VGND VPWR VPWR _1635_/B sky130_fd_sc_hd__nor2_1
XFILLER_55_237 VGND VGND VPWR VPWR sky130_fd_sc_hd__decap_3
XTAP_TAPCELL_ROW_53_449 VGND VPWR sky130_fd_sc_hd__tapvpwrvgnd_1
XFILLER_23_156 VGND VGND VPWR VPWR sky130_fd_sc_hd__decap_3
XFILLER_23_189 VGND VGND VPWR VPWR sky130_fd_sc_hd__fill_1
XFILLER_11_34 VGND VGND VPWR VPWR sky130_fd_sc_hd__decap_3
XFILLER_46_204 VGND VGND VPWR VPWR sky130_fd_sc_hd__decap_3
XFILLER_46_237 VGND VGND VPWR VPWR sky130_fd_sc_hd__decap_3
XFILLER_36_64 VGND VGND VPWR VPWR sky130_fd_sc_hd__decap_3
XFILLER_14_101 VGND VGND VPWR VPWR sky130_fd_sc_hd__decap_3
XFILLER_54_270 VGND VGND VPWR VPWR sky130_fd_sc_hd__decap_3
XFILLER_14_189 VGND VGND VPWR VPWR sky130_fd_sc_hd__decap_3
XTAP_TAPCELL_ROW_9_182 VGND VPWR sky130_fd_sc_hd__tapvpwrvgnd_1
XFILLER_45_281 VGND VGND VPWR VPWR sky130_fd_sc_hd__decap_3
XFILLER_45_270 VGND VGND VPWR VPWR sky130_fd_sc_hd__decap_3
XFILLER_60_240 VGND VGND VPWR VPWR sky130_fd_sc_hd__decap_3
XFILLER_60_262 VGND VGND VPWR VPWR sky130_fd_sc_hd__decap_3
XFILLER_20_104 VGND VGND VPWR VPWR sky130_fd_sc_hd__fill_1
X_1984_ _1984_/A _1984_/B VGND VGND VPWR VPWR _2068_/A sky130_fd_sc_hd__xnor2_1
XFILLER_60_284 VGND VGND VPWR VPWR sky130_fd_sc_hd__decap_3
XPHY_EDGE_ROW_21_Left_82 VGND VGND VPWR VPWR sky130_fd_sc_hd__decap_3
XFILLER_9_182 VGND VGND VPWR VPWR sky130_fd_sc_hd__decap_3
X_2605_ _2605_/A _2605_/B VGND VGND VPWR VPWR _2606_/B sky130_fd_sc_hd__xnor2_1
X_2536_ _2536_/A _2536_/B VGND VGND VPWR VPWR _2552_/A sky130_fd_sc_hd__xnor2_2
X_2467_ _2656_/B _2719_/B VGND VGND VPWR VPWR _2468_/B sky130_fd_sc_hd__or2_1
X_1418_ _1398_/Y _1415_/Y _1416_/X VGND VGND VPWR VPWR _1886_/B sky130_fd_sc_hd__o21ai_2
X_2398_ _2398_/A _2398_/B VGND VGND VPWR VPWR _2483_/A sky130_fd_sc_hd__xnor2_4
XFILLER_28_226 VGND VGND VPWR VPWR sky130_fd_sc_hd__decap_3
XFILLER_28_215 VGND VGND VPWR VPWR sky130_fd_sc_hd__fill_1
XFILLER_28_259 VGND VGND VPWR VPWR sky130_fd_sc_hd__fill_1
XFILLER_51_273 VGND VGND VPWR VPWR sky130_fd_sc_hd__decap_3
XFILLER_11_126 VGND VGND VPWR VPWR sky130_fd_sc_hd__decap_3
XFILLER_51_284 VGND VGND VPWR VPWR sky130_fd_sc_hd__decap_3
XFILLER_7_119 VGND VGND VPWR VPWR sky130_fd_sc_hd__decap_3
XFILLER_7_108 VGND VGND VPWR VPWR sky130_fd_sc_hd__decap_3
XFILLER_22_44 VGND VGND VPWR VPWR sky130_fd_sc_hd__fill_1
XFILLER_59_340 VGND VGND VPWR VPWR sky130_fd_sc_hd__decap_3
XFILLER_47_30 VGND VGND VPWR VPWR sky130_fd_sc_hd__decap_3
XFILLER_47_52 VGND VGND VPWR VPWR sky130_fd_sc_hd__decap_3
XFILLER_19_237 VGND VGND VPWR VPWR sky130_fd_sc_hd__decap_3
XFILLER_47_85 VGND VGND VPWR VPWR sky130_fd_sc_hd__fill_2
XFILLER_27_281 VGND VGND VPWR VPWR sky130_fd_sc_hd__decap_3
XFILLER_8_24 VGND VGND VPWR VPWR sky130_fd_sc_hd__decap_3
XFILLER_8_35 VGND VGND VPWR VPWR sky130_fd_sc_hd__decap_3
XFILLER_8_68 VGND VGND VPWR VPWR sky130_fd_sc_hd__decap_3
XFILLER_6_141 VGND VGND VPWR VPWR sky130_fd_sc_hd__decap_3
X_2321_ _2321_/A _2321_/B _2321_/C VGND VGND VPWR VPWR _2338_/A sky130_fd_sc_hd__or3_1
X_2252_ _2252_/A _2252_/B VGND VGND VPWR VPWR _2288_/A sky130_fd_sc_hd__xnor2_1
XFILLER_26_3 VGND VGND VPWR VPWR sky130_fd_sc_hd__fill_1
X_2183_ _2196_/A _2196_/B VGND VGND VPWR VPWR _2183_/X sky130_fd_sc_hd__or2_1
XFILLER_33_284 VGND VGND VPWR VPWR sky130_fd_sc_hd__decap_3
X_1967_ _1967_/A _1967_/B _1967_/C VGND VGND VPWR VPWR _1980_/B sky130_fd_sc_hd__and3_1
X_1898_ _1898_/A _2770_/Q VGND VGND VPWR VPWR _1899_/B sky130_fd_sc_hd__nor2_1
X_2519_ _2643_/C _2519_/B VGND VGND VPWR VPWR _2519_/X sky130_fd_sc_hd__and2_1
XFILLER_56_321 VGND VGND VPWR VPWR sky130_fd_sc_hd__decap_3
XFILLER_56_354 VGND VGND VPWR VPWR sky130_fd_sc_hd__decap_3
XFILLER_17_44 VGND VGND VPWR VPWR sky130_fd_sc_hd__decap_3
XFILLER_16_218 VGND VGND VPWR VPWR sky130_fd_sc_hd__decap_3
XFILLER_24_251 VGND VGND VPWR VPWR sky130_fd_sc_hd__fill_1
XFILLER_33_98 VGND VGND VPWR VPWR sky130_fd_sc_hd__decap_3
XFILLER_3_133 VGND VGND VPWR VPWR sky130_fd_sc_hd__decap_3
XFILLER_3_122 VGND VGND VPWR VPWR sky130_fd_sc_hd__decap_3
XFILLER_3_166 VGND VGND VPWR VPWR sky130_fd_sc_hd__fill_2
XFILLER_58_62 VGND VGND VPWR VPWR sky130_fd_sc_hd__decap_3
XFILLER_12_9 VGND VGND VPWR VPWR sky130_fd_sc_hd__decap_3
XFILLER_47_343 VGND VGND VPWR VPWR sky130_fd_sc_hd__decap_3
XFILLER_47_332 VGND VGND VPWR VPWR sky130_fd_sc_hd__decap_3
XTAP_TAPCELL_ROW_17_235 VGND VPWR sky130_fd_sc_hd__tapvpwrvgnd_1
XFILLER_15_262 VGND VGND VPWR VPWR sky130_fd_sc_hd__decap_3
XFILLER_15_240 VGND VGND VPWR VPWR sky130_fd_sc_hd__decap_3
XFILLER_30_221 VGND VGND VPWR VPWR sky130_fd_sc_hd__decap_3
X_1821_ _1972_/A _1970_/A VGND VGND VPWR VPWR _1897_/B sky130_fd_sc_hd__xnor2_1
XFILLER_30_298 VGND VGND VPWR VPWR sky130_fd_sc_hd__decap_3
XFILLER_30_265 VGND VGND VPWR VPWR sky130_fd_sc_hd__decap_3
X_1752_ _1752_/A _1752_/B VGND VGND VPWR VPWR _1765_/A sky130_fd_sc_hd__xnor2_1
X_1683_ _1683_/A _1683_/B VGND VGND VPWR VPWR _1684_/B sky130_fd_sc_hd__xor2_1
X_2304_ _2305_/A _2305_/B VGND VGND VPWR VPWR _2304_/Y sky130_fd_sc_hd__nand2b_1
XFILLER_57_107 VGND VGND VPWR VPWR sky130_fd_sc_hd__decap_3
X_2235_ _2233_/A _2233_/B _2234_/X VGND VGND VPWR VPWR _2238_/B sky130_fd_sc_hd__a21oi_1
XFILLER_38_321 VGND VGND VPWR VPWR sky130_fd_sc_hd__decap_3
X_2166_ _2182_/A _2182_/B VGND VGND VPWR VPWR _2166_/Y sky130_fd_sc_hd__nand2_1
XTAP_TAPCELL_ROW_0_125 VGND VPWR sky130_fd_sc_hd__tapvpwrvgnd_1
XFILLER_53_302 VGND VGND VPWR VPWR sky130_fd_sc_hd__decap_3
X_2097_ _2153_/A _2153_/B VGND VGND VPWR VPWR _2108_/A sky130_fd_sc_hd__nand2_1
XFILLER_53_346 VGND VGND VPWR VPWR sky130_fd_sc_hd__decap_3
XFILLER_53_335 VGND VGND VPWR VPWR sky130_fd_sc_hd__fill_1
XPHY_EDGE_ROW_3_Right_3 VGND VGND VPWR VPWR sky130_fd_sc_hd__decap_3
XFILLER_0_125 VGND VGND VPWR VPWR sky130_fd_sc_hd__decap_3
Xclkbuf_1_1__f_clk clkbuf_0_clk/X VGND VGND VPWR VPWR _2777_/CLK sky130_fd_sc_hd__clkbuf_16
XFILLER_0_147 VGND VGND VPWR VPWR sky130_fd_sc_hd__decap_3
XFILLER_0_169 VGND VGND VPWR VPWR sky130_fd_sc_hd__decap_3
XFILLER_48_118 VGND VGND VPWR VPWR sky130_fd_sc_hd__decap_3
XFILLER_29_321 VGND VGND VPWR VPWR sky130_fd_sc_hd__decap_3
XFILLER_28_32 VGND VGND VPWR VPWR sky130_fd_sc_hd__decap_3
XFILLER_29_354 VGND VGND VPWR VPWR sky130_fd_sc_hd__decap_3
XFILLER_28_54 VGND VGND VPWR VPWR sky130_fd_sc_hd__decap_3
XFILLER_56_162 VGND VGND VPWR VPWR sky130_fd_sc_hd__decap_3
XFILLER_44_302 VGND VGND VPWR VPWR sky130_fd_sc_hd__decap_3
XFILLER_44_335 VGND VGND VPWR VPWR sky130_fd_sc_hd__decap_3
XTAP_TAPCELL_ROW_14_216 VGND VPWR sky130_fd_sc_hd__tapvpwrvgnd_1
XFILLER_8_203 VGND VGND VPWR VPWR sky130_fd_sc_hd__decap_3
XFILLER_12_287 VGND VGND VPWR VPWR sky130_fd_sc_hd__decap_3
XTAP_TAPCELL_ROW_22_260 VGND VPWR sky130_fd_sc_hd__tapvpwrvgnd_1
XFILLER_60_63 VGND VGND VPWR VPWR sky130_fd_sc_hd__decap_3
XFILLER_60_41 VGND VGND VPWR VPWR sky130_fd_sc_hd__decap_3
XFILLER_60_85 VGND VGND VPWR VPWR sky130_fd_sc_hd__decap_3
XFILLER_5_36 VGND VGND VPWR VPWR sky130_fd_sc_hd__decap_3
XFILLER_5_69 VGND VGND VPWR VPWR sky130_fd_sc_hd__decap_3
XFILLER_39_107 VGND VGND VPWR VPWR sky130_fd_sc_hd__decap_3
X_2020_ _2021_/A _2021_/B VGND VGND VPWR VPWR _2022_/B sky130_fd_sc_hd__nand2_1
XFILLER_50_327 VGND VGND VPWR VPWR sky130_fd_sc_hd__decap_3
X_1804_ _1804_/A _1883_/B VGND VGND VPWR VPWR _1807_/B sky130_fd_sc_hd__nor2_1
X_1735_ _2000_/A _2726_/A _2123_/S VGND VGND VPWR VPWR _1736_/B sky130_fd_sc_hd__a21oi_1
X_1666_ _1666_/A _1666_/B VGND VGND VPWR VPWR _1817_/A sky130_fd_sc_hd__xnor2_1
X_1597_ _1597_/A _1656_/A VGND VGND VPWR VPWR _1597_/Y sky130_fd_sc_hd__nor2_1
X_2218_ _2262_/A _2263_/B VGND VGND VPWR VPWR _2221_/A sky130_fd_sc_hd__nor2_1
XFILLER_38_173 VGND VGND VPWR VPWR sky130_fd_sc_hd__decap_3
X_2149_ _2149_/A _2149_/B _2089_/Y _2286_/B VGND VGND VPWR VPWR _2150_/C sky130_fd_sc_hd__or4bb_1
XFILLER_53_110 VGND VGND VPWR VPWR sky130_fd_sc_hd__fill_2
XFILLER_26_324 VGND VGND VPWR VPWR sky130_fd_sc_hd__decap_3
XFILLER_53_165 VGND VGND VPWR VPWR sky130_fd_sc_hd__decap_3
XFILLER_5_228 VGND VGND VPWR VPWR sky130_fd_sc_hd__fill_1
XFILLER_30_77 VGND VGND VPWR VPWR sky130_fd_sc_hd__fill_2
XFILLER_39_42 VGND VGND VPWR VPWR sky130_fd_sc_hd__decap_3
XFILLER_29_140 VGND VGND VPWR VPWR sky130_fd_sc_hd__fill_2
XFILLER_55_30 VGND VGND VPWR VPWR sky130_fd_sc_hd__decap_3
XFILLER_55_63 VGND VGND VPWR VPWR sky130_fd_sc_hd__fill_1
XFILLER_32_305 VGND VGND VPWR VPWR sky130_fd_sc_hd__decap_3
XFILLER_32_338 VGND VGND VPWR VPWR sky130_fd_sc_hd__decap_3
X_1520_ _1515_/Y _1518_/B _1718_/A VGND VGND VPWR VPWR _1646_/A sky130_fd_sc_hd__o21bai_1
XFILLER_58_6 VGND VGND VPWR VPWR sky130_fd_sc_hd__decap_3
X_1451_ _2776_/Q _1451_/B VGND VGND VPWR VPWR _1451_/X sky130_fd_sc_hd__and2_1
X_1382_ _2775_/Q VGND VGND VPWR VPWR _2437_/A sky130_fd_sc_hd__inv_2
X_2003_ _2003_/A _2003_/B VGND VGND VPWR VPWR _2005_/B sky130_fd_sc_hd__xnor2_1
XFILLER_35_110 VGND VGND VPWR VPWR sky130_fd_sc_hd__fill_2
XFILLER_35_154 VGND VGND VPWR VPWR sky130_fd_sc_hd__decap_3
XFILLER_50_124 VGND VGND VPWR VPWR sky130_fd_sc_hd__decap_3
XFILLER_35_198 VGND VGND VPWR VPWR sky130_fd_sc_hd__decap_3
XFILLER_23_316 VGND VGND VPWR VPWR sky130_fd_sc_hd__decap_3
XFILLER_50_168 VGND VGND VPWR VPWR sky130_fd_sc_hd__decap_3
X_2767_ clkload0/A _2767_/D fanout47/X VGND VGND VPWR VPWR _2767_/Q sky130_fd_sc_hd__dfrtp_4
X_1718_ _1718_/A _1718_/B VGND VGND VPWR VPWR _1720_/B sky130_fd_sc_hd__or2_1
X_2698_ input6/X _2698_/B VGND VGND VPWR VPWR uo_out[3] sky130_fd_sc_hd__xnor2_4
X_1649_ _1647_/A _1647_/B _1724_/A VGND VGND VPWR VPWR _1651_/B sky130_fd_sc_hd__a21oi_1
XFILLER_58_213 VGND VGND VPWR VPWR sky130_fd_sc_hd__decap_3
XFILLER_58_246 VGND VGND VPWR VPWR sky130_fd_sc_hd__decap_3
XFILLER_58_268 VGND VGND VPWR VPWR sky130_fd_sc_hd__decap_3
XTAP_TAPCELL_ROW_56_469 VGND VPWR sky130_fd_sc_hd__tapvpwrvgnd_1
XFILLER_41_113 VGND VGND VPWR VPWR sky130_fd_sc_hd__decap_3
XFILLER_41_102 VGND VGND VPWR VPWR sky130_fd_sc_hd__decap_3
XFILLER_25_33 VGND VGND VPWR VPWR sky130_fd_sc_hd__decap_3
XFILLER_25_88 VGND VGND VPWR VPWR sky130_fd_sc_hd__decap_3
XFILLER_14_349 VGND VGND VPWR VPWR sky130_fd_sc_hd__decap_3
XFILLER_41_179 VGND VGND VPWR VPWR sky130_fd_sc_hd__decap_3
XFILLER_41_21 VGND VGND VPWR VPWR sky130_fd_sc_hd__decap_3
XFILLER_41_87 VGND VGND VPWR VPWR sky130_fd_sc_hd__decap_3
XFILLER_2_15 VGND VGND VPWR VPWR sky130_fd_sc_hd__decap_3
XFILLER_1_253 VGND VGND VPWR VPWR sky130_fd_sc_hd__fill_1
XFILLER_49_257 VGND VGND VPWR VPWR sky130_fd_sc_hd__decap_3
XFILLER_2_59 VGND VGND VPWR VPWR sky130_fd_sc_hd__decap_3
XTAP_TAPCELL_ROW_47_414 VGND VPWR sky130_fd_sc_hd__tapvpwrvgnd_1
XFILLER_57_290 VGND VGND VPWR VPWR sky130_fd_sc_hd__decap_3
XFILLER_17_132 VGND VGND VPWR VPWR sky130_fd_sc_hd__decap_3
XFILLER_32_102 VGND VGND VPWR VPWR sky130_fd_sc_hd__decap_3
XFILLER_32_146 VGND VGND VPWR VPWR sky130_fd_sc_hd__decap_3
XFILLER_17_198 VGND VGND VPWR VPWR sky130_fd_sc_hd__decap_3
XFILLER_9_331 VGND VGND VPWR VPWR sky130_fd_sc_hd__fill_2
XFILLER_40_190 VGND VGND VPWR VPWR sky130_fd_sc_hd__decap_3
X_2621_ _2619_/X _2620_/Y _2609_/Y VGND VGND VPWR VPWR _2691_/B sky130_fd_sc_hd__a21oi_1
X_2552_ _2552_/A _2562_/A VGND VGND VPWR VPWR _2580_/B sky130_fd_sc_hd__xnor2_1
XFILLER_56_3 VGND VGND VPWR VPWR sky130_fd_sc_hd__decap_3
X_1503_ _2206_/A _2057_/A VGND VGND VPWR VPWR _1972_/B sky130_fd_sc_hd__or2_1
X_2483_ _2483_/A _2566_/A VGND VGND VPWR VPWR _2560_/A sky130_fd_sc_hd__xnor2_2
X_1434_ _1813_/A _1434_/B _1434_/C VGND VGND VPWR VPWR _1435_/B sky130_fd_sc_hd__nor3_1
XFILLER_55_249 VGND VGND VPWR VPWR sky130_fd_sc_hd__decap_3
XFILLER_48_290 VGND VGND VPWR VPWR sky130_fd_sc_hd__decap_3
XFILLER_23_102 VGND VGND VPWR VPWR sky130_fd_sc_hd__decap_3
XFILLER_11_308 VGND VGND VPWR VPWR sky130_fd_sc_hd__decap_3
XFILLER_23_179 VGND VGND VPWR VPWR sky130_fd_sc_hd__decap_3
XFILLER_11_68 VGND VGND VPWR VPWR sky130_fd_sc_hd__decap_3
XFILLER_46_249 VGND VGND VPWR VPWR sky130_fd_sc_hd__decap_3
XFILLER_46_216 VGND VGND VPWR VPWR sky130_fd_sc_hd__decap_3
XFILLER_36_21 VGND VGND VPWR VPWR sky130_fd_sc_hd__fill_1
XFILLER_14_113 VGND VGND VPWR VPWR sky130_fd_sc_hd__decap_3
XFILLER_36_76 VGND VGND VPWR VPWR sky130_fd_sc_hd__decap_3
XFILLER_54_282 VGND VGND VPWR VPWR sky130_fd_sc_hd__decap_3
XFILLER_14_179 VGND VGND VPWR VPWR sky130_fd_sc_hd__decap_3
XFILLER_10_352 VGND VGND VPWR VPWR sky130_fd_sc_hd__decap_3
XFILLER_6_312 VGND VGND VPWR VPWR sky130_fd_sc_hd__decap_3
XFILLER_42_9 VGND VGND VPWR VPWR sky130_fd_sc_hd__decap_3
XTAP_TAPCELL_ROW_9_183 VGND VPWR sky130_fd_sc_hd__tapvpwrvgnd_1
XFILLER_60_274 VGND VGND VPWR VPWR sky130_fd_sc_hd__decap_3
X_1983_ _1984_/A _1984_/B VGND VGND VPWR VPWR _1983_/Y sky130_fd_sc_hd__nand2_1
XFILLER_20_138 VGND VGND VPWR VPWR sky130_fd_sc_hd__fill_2
XFILLER_9_161 VGND VGND VPWR VPWR sky130_fd_sc_hd__decap_3
XFILLER_20_149 VGND VGND VPWR VPWR sky130_fd_sc_hd__decap_3
XFILLER_9_194 VGND VGND VPWR VPWR sky130_fd_sc_hd__fill_1
X_2604_ _2660_/B VGND VGND VPWR VPWR _2640_/B sky130_fd_sc_hd__inv_2
X_2535_ _2472_/Y _2535_/B VGND VGND VPWR VPWR _2536_/B sky130_fd_sc_hd__and2b_1
X_2466_ input3/X input4/X VGND VGND VPWR VPWR _2466_/Y sky130_fd_sc_hd__nand2b_1
X_1417_ _1398_/Y _1415_/Y _1416_/X VGND VGND VPWR VPWR _2021_/B sky130_fd_sc_hd__o21a_1
X_2397_ _2431_/A _2397_/B VGND VGND VPWR VPWR _2434_/A sky130_fd_sc_hd__or2_1
XFILLER_3_80 VGND VGND VPWR VPWR sky130_fd_sc_hd__decap_3
XFILLER_36_271 VGND VGND VPWR VPWR sky130_fd_sc_hd__decap_3
XFILLER_51_230 VGND VGND VPWR VPWR sky130_fd_sc_hd__decap_3
XFILLER_11_105 VGND VGND VPWR VPWR sky130_fd_sc_hd__decap_3
XFILLER_11_138 VGND VGND VPWR VPWR sky130_fd_sc_hd__decap_3
XFILLER_51_296 VGND VGND VPWR VPWR sky130_fd_sc_hd__decap_3
XFILLER_22_12 VGND VGND VPWR VPWR sky130_fd_sc_hd__decap_3
XFILLER_3_337 VGND VGND VPWR VPWR sky130_fd_sc_hd__decap_3
XTAP_TAPCELL_ROW_6_164 VGND VPWR sky130_fd_sc_hd__tapvpwrvgnd_1
XFILLER_59_352 VGND VGND VPWR VPWR sky130_fd_sc_hd__decap_3
XFILLER_47_64 VGND VGND VPWR VPWR sky130_fd_sc_hd__decap_3
XFILLER_34_219 VGND VGND VPWR VPWR sky130_fd_sc_hd__decap_3
XFILLER_27_271 VGND VGND VPWR VPWR sky130_fd_sc_hd__decap_3
XFILLER_42_230 VGND VGND VPWR VPWR sky130_fd_sc_hd__decap_3
XFILLER_10_160 VGND VGND VPWR VPWR sky130_fd_sc_hd__fill_1
XFILLER_10_193 VGND VGND VPWR VPWR sky130_fd_sc_hd__decap_3
XFILLER_6_153 VGND VGND VPWR VPWR sky130_fd_sc_hd__fill_1
XFILLER_6_164 VGND VGND VPWR VPWR sky130_fd_sc_hd__decap_3
XFILLER_40_6 VGND VGND VPWR VPWR sky130_fd_sc_hd__decap_3
X_2320_ _2298_/A _2318_/Y _2317_/Y _2311_/Y VGND VGND VPWR VPWR _2321_/C sky130_fd_sc_hd__o211a_1
X_2251_ _2252_/A _2252_/B VGND VGND VPWR VPWR _2251_/Y sky130_fd_sc_hd__nand2b_1
X_2182_ _2182_/A _2182_/B VGND VGND VPWR VPWR _2196_/B sky130_fd_sc_hd__xnor2_1
XFILLER_19_3 VGND VGND VPWR VPWR sky130_fd_sc_hd__decap_3
XFILLER_25_219 VGND VGND VPWR VPWR sky130_fd_sc_hd__decap_3
XFILLER_18_282 VGND VGND VPWR VPWR sky130_fd_sc_hd__decap_3
XFILLER_33_296 VGND VGND VPWR VPWR sky130_fd_sc_hd__decap_3
X_1966_ _1967_/A _1967_/B _1967_/C VGND VGND VPWR VPWR _1981_/A sky130_fd_sc_hd__a21oi_1
X_1897_ _1995_/A _1897_/B VGND VGND VPWR VPWR _1902_/A sky130_fd_sc_hd__xnor2_1
XFILLER_0_307 VGND VGND VPWR VPWR sky130_fd_sc_hd__fill_1
X_2518_ _2521_/A _2518_/B VGND VGND VPWR VPWR _2519_/B sky130_fd_sc_hd__or2_1
X_2449_ _2700_/B _2449_/B VGND VGND VPWR VPWR _2694_/C sky130_fd_sc_hd__nand2_1
XFILLER_56_333 VGND VGND VPWR VPWR sky130_fd_sc_hd__decap_3
XPHY_EDGE_ROW_49_Left_110 VGND VGND VPWR VPWR sky130_fd_sc_hd__decap_3
XFILLER_33_66 VGND VGND VPWR VPWR sky130_fd_sc_hd__fill_2
XFILLER_3_101 VGND VGND VPWR VPWR sky130_fd_sc_hd__decap_3
XFILLER_3_145 VGND VGND VPWR VPWR sky130_fd_sc_hd__decap_3
XFILLER_58_74 VGND VGND VPWR VPWR sky130_fd_sc_hd__decap_3
XFILLER_58_41 VGND VGND VPWR VPWR sky130_fd_sc_hd__decap_3
XFILLER_58_85 VGND VGND VPWR VPWR sky130_fd_sc_hd__decap_3
XFILLER_47_311 VGND VGND VPWR VPWR sky130_fd_sc_hd__decap_3
XFILLER_47_300 VGND VGND VPWR VPWR sky130_fd_sc_hd__fill_2
XFILLER_47_355 VGND VGND VPWR VPWR sky130_fd_sc_hd__decap_3
X_1820_ _2217_/A _1820_/B VGND VGND VPWR VPWR _1970_/A sky130_fd_sc_hd__nor2_1
XTAP_TAPCELL_ROW_25_280 VGND VPWR sky130_fd_sc_hd__tapvpwrvgnd_1
XFILLER_30_233 VGND VGND VPWR VPWR sky130_fd_sc_hd__fill_1
XFILLER_30_288 VGND VGND VPWR VPWR sky130_fd_sc_hd__decap_3
X_1751_ _1751_/A _1751_/B VGND VGND VPWR VPWR _1751_/Y sky130_fd_sc_hd__xnor2_1
X_1682_ _1972_/A _1682_/B VGND VGND VPWR VPWR _1683_/B sky130_fd_sc_hd__xnor2_1
X_2303_ _2300_/Y _2303_/B VGND VGND VPWR VPWR _2305_/B sky130_fd_sc_hd__nand2b_1
X_2234_ _2248_/A _2248_/B VGND VGND VPWR VPWR _2234_/X sky130_fd_sc_hd__and2_1
XFILLER_57_119 VGND VGND VPWR VPWR sky130_fd_sc_hd__decap_3
X_2165_ _2197_/A _2197_/B _2154_/X VGND VGND VPWR VPWR _2182_/B sky130_fd_sc_hd__o21ai_2
XFILLER_38_355 VGND VGND VPWR VPWR sky130_fd_sc_hd__decap_3
XTAP_TAPCELL_ROW_0_126 VGND VPWR sky130_fd_sc_hd__tapvpwrvgnd_1
XFILLER_53_314 VGND VGND VPWR VPWR sky130_fd_sc_hd__decap_3
XFILLER_0_70 VGND VGND VPWR VPWR sky130_fd_sc_hd__decap_3
X_2096_ _2096_/A _2096_/B VGND VGND VPWR VPWR _2153_/B sky130_fd_sc_hd__nor2_1
XFILLER_0_92 VGND VGND VPWR VPWR sky130_fd_sc_hd__decap_3
XFILLER_53_358 VGND VGND VPWR VPWR sky130_fd_sc_hd__decap_3
XFILLER_21_211 VGND VGND VPWR VPWR sky130_fd_sc_hd__decap_3
X_1949_ _1949_/A _1949_/B VGND VGND VPWR VPWR _2026_/A sky130_fd_sc_hd__or2_1
XFILLER_0_137 VGND VGND VPWR VPWR sky130_fd_sc_hd__decap_3
XFILLER_0_159 VGND VGND VPWR VPWR sky130_fd_sc_hd__decap_3
XFILLER_29_311 VGND VGND VPWR VPWR sky130_fd_sc_hd__decap_3
XFILLER_28_22 VGND VGND VPWR VPWR sky130_fd_sc_hd__decap_3
XFILLER_28_11 VGND VGND VPWR VPWR sky130_fd_sc_hd__fill_2
XFILLER_29_333 VGND VGND VPWR VPWR sky130_fd_sc_hd__decap_3
XFILLER_28_66 VGND VGND VPWR VPWR sky130_fd_sc_hd__decap_3
XFILLER_56_174 VGND VGND VPWR VPWR sky130_fd_sc_hd__decap_3
XFILLER_56_141 VGND VGND VPWR VPWR sky130_fd_sc_hd__decap_3
XFILLER_28_88 VGND VGND VPWR VPWR sky130_fd_sc_hd__decap_3
XFILLER_44_347 VGND VGND VPWR VPWR sky130_fd_sc_hd__decap_3
XFILLER_44_32 VGND VGND VPWR VPWR sky130_fd_sc_hd__decap_3
XFILLER_44_21 VGND VGND VPWR VPWR sky130_fd_sc_hd__decap_3
XTAP_TAPCELL_ROW_14_217 VGND VPWR sky130_fd_sc_hd__tapvpwrvgnd_1
XFILLER_44_65 VGND VGND VPWR VPWR sky130_fd_sc_hd__decap_3
XFILLER_12_222 VGND VGND VPWR VPWR sky130_fd_sc_hd__decap_3
XFILLER_44_98 VGND VGND VPWR VPWR sky130_fd_sc_hd__decap_3
XFILLER_8_226 VGND VGND VPWR VPWR sky130_fd_sc_hd__decap_3
XFILLER_12_299 VGND VGND VPWR VPWR sky130_fd_sc_hd__decap_3
XTAP_TAPCELL_ROW_22_261 VGND VPWR sky130_fd_sc_hd__tapvpwrvgnd_1
XFILLER_8_259 VGND VGND VPWR VPWR sky130_fd_sc_hd__decap_3
XFILLER_8_248 VGND VGND VPWR VPWR sky130_fd_sc_hd__decap_3
XFILLER_60_53 VGND VGND VPWR VPWR sky130_fd_sc_hd__decap_3
XFILLER_60_97 VGND VGND VPWR VPWR sky130_fd_sc_hd__decap_3
XFILLER_60_75 VGND VGND VPWR VPWR sky130_fd_sc_hd__decap_3
XFILLER_5_15 VGND VGND VPWR VPWR sky130_fd_sc_hd__decap_3
XFILLER_5_48 VGND VGND VPWR VPWR sky130_fd_sc_hd__fill_1
XPHY_EDGE_ROW_13_Right_13 VGND VGND VPWR VPWR sky130_fd_sc_hd__decap_3
XFILLER_35_358 VGND VGND VPWR VPWR sky130_fd_sc_hd__decap_3
XFILLER_50_339 VGND VGND VPWR VPWR sky130_fd_sc_hd__decap_3
X_1803_ _1803_/A _1803_/B VGND VGND VPWR VPWR _1883_/B sky130_fd_sc_hd__xnor2_1
XPHY_EDGE_ROW_22_Right_22 VGND VGND VPWR VPWR sky130_fd_sc_hd__decap_3
X_1734_ _2045_/B _2726_/A VGND VGND VPWR VPWR _2123_/S sky130_fd_sc_hd__nor2_1
XFILLER_7_292 VGND VGND VPWR VPWR sky130_fd_sc_hd__decap_3
X_1665_ _1666_/A _1666_/B VGND VGND VPWR VPWR _1675_/A sky130_fd_sc_hd__and2b_1
X_1596_ _1596_/A _1596_/B VGND VGND VPWR VPWR _1618_/A sky130_fd_sc_hd__xor2_1
XPHY_EDGE_ROW_31_Right_31 VGND VGND VPWR VPWR sky130_fd_sc_hd__decap_3
X_2217_ _2217_/A _2217_/B VGND VGND VPWR VPWR _2263_/B sky130_fd_sc_hd__nand2_1
X_2148_ _2735_/A _2084_/B _2286_/B _2091_/X _2089_/Y VGND VGND VPWR VPWR _2150_/B
+ sky130_fd_sc_hd__a32o_1
XFILLER_38_185 VGND VGND VPWR VPWR sky130_fd_sc_hd__decap_3
X_2079_ _2079_/A _2079_/B VGND VGND VPWR VPWR _2380_/A sky130_fd_sc_hd__xnor2_2
XFILLER_41_306 VGND VGND VPWR VPWR sky130_fd_sc_hd__decap_3
XPHY_EDGE_ROW_40_Right_40 VGND VGND VPWR VPWR sky130_fd_sc_hd__decap_3
XFILLER_5_207 VGND VGND VPWR VPWR sky130_fd_sc_hd__decap_3
XFILLER_30_12 VGND VGND VPWR VPWR sky130_fd_sc_hd__decap_3
XFILLER_30_45 VGND VGND VPWR VPWR sky130_fd_sc_hd__decap_3
XFILLER_39_21 VGND VGND VPWR VPWR sky130_fd_sc_hd__decap_3
XFILLER_39_54 VGND VGND VPWR VPWR sky130_fd_sc_hd__fill_2
XFILLER_39_76 VGND VGND VPWR VPWR sky130_fd_sc_hd__decap_3
XFILLER_29_152 VGND VGND VPWR VPWR sky130_fd_sc_hd__decap_3
XFILLER_55_42 VGND VGND VPWR VPWR sky130_fd_sc_hd__decap_3
XFILLER_44_111 VGND VGND VPWR VPWR sky130_fd_sc_hd__decap_3
XFILLER_17_314 VGND VGND VPWR VPWR sky130_fd_sc_hd__fill_1
XFILLER_55_86 VGND VGND VPWR VPWR sky130_fd_sc_hd__fill_1
XFILLER_44_133 VGND VGND VPWR VPWR sky130_fd_sc_hd__decap_3
XFILLER_44_188 VGND VGND VPWR VPWR sky130_fd_sc_hd__decap_3
XFILLER_4_251 VGND VGND VPWR VPWR sky130_fd_sc_hd__fill_1
X_1450_ _2775_/Q _2776_/Q _1451_/B _2729_/B VGND VGND VPWR VPWR _1450_/X sky130_fd_sc_hd__or4_2
XFILLER_4_284 VGND VGND VPWR VPWR sky130_fd_sc_hd__fill_1
X_1381_ _2774_/Q VGND VGND VPWR VPWR _2441_/A sky130_fd_sc_hd__inv_2
X_2002_ _1904_/Y _1977_/A _1975_/X _1978_/X VGND VGND VPWR VPWR _2005_/A sky130_fd_sc_hd__a31oi_2
XFILLER_35_122 VGND VGND VPWR VPWR sky130_fd_sc_hd__decap_3
XFILLER_35_166 VGND VGND VPWR VPWR sky130_fd_sc_hd__fill_2
X_2766_ clkload0/A _2766_/D fanout47/X VGND VGND VPWR VPWR _2766_/Q sky130_fd_sc_hd__dfrtp_2
X_1717_ _2000_/A _1717_/B VGND VGND VPWR VPWR _1718_/B sky130_fd_sc_hd__nor2_1
X_2697_ _2696_/A _2672_/X _2693_/X _2696_/X VGND VGND VPWR VPWR _2698_/B sky130_fd_sc_hd__a22oi_4
X_1648_ _1723_/A _1723_/B VGND VGND VPWR VPWR _1724_/A sky130_fd_sc_hd__nor2_1
XFILLER_6_80 VGND VGND VPWR VPWR sky130_fd_sc_hd__decap_3
X_1579_ _1579_/A _1579_/B VGND VGND VPWR VPWR _1580_/B sky130_fd_sc_hd__nor2_1
XFILLER_58_225 VGND VGND VPWR VPWR sky130_fd_sc_hd__decap_3
XFILLER_26_100 VGND VGND VPWR VPWR sky130_fd_sc_hd__decap_3
XFILLER_26_133 VGND VGND VPWR VPWR sky130_fd_sc_hd__decap_3
XFILLER_41_125 VGND VGND VPWR VPWR sky130_fd_sc_hd__decap_3
XFILLER_41_66 VGND VGND VPWR VPWR sky130_fd_sc_hd__decap_3
XFILLER_41_44 VGND VGND VPWR VPWR sky130_fd_sc_hd__decap_3
XFILLER_41_99 VGND VGND VPWR VPWR sky130_fd_sc_hd__decap_3
XFILLER_1_210 VGND VGND VPWR VPWR sky130_fd_sc_hd__fill_2
XFILLER_49_203 VGND VGND VPWR VPWR sky130_fd_sc_hd__decap_3
XFILLER_1_265 VGND VGND VPWR VPWR sky130_fd_sc_hd__fill_1
XFILLER_49_225 VGND VGND VPWR VPWR sky130_fd_sc_hd__decap_3
XFILLER_2_38 VGND VGND VPWR VPWR sky130_fd_sc_hd__decap_3
XFILLER_2_27 VGND VGND VPWR VPWR sky130_fd_sc_hd__fill_1
XFILLER_49_269 VGND VGND VPWR VPWR sky130_fd_sc_hd__decap_3
XTAP_TAPCELL_ROW_47_415 VGND VPWR sky130_fd_sc_hd__tapvpwrvgnd_1
XFILLER_17_111 VGND VGND VPWR VPWR sky130_fd_sc_hd__fill_1
XFILLER_17_144 VGND VGND VPWR VPWR sky130_fd_sc_hd__decap_3
XFILLER_32_114 VGND VGND VPWR VPWR sky130_fd_sc_hd__decap_3
XFILLER_17_177 VGND VGND VPWR VPWR sky130_fd_sc_hd__decap_3
XFILLER_32_136 VGND VGND VPWR VPWR sky130_fd_sc_hd__decap_3
XFILLER_9_310 VGND VGND VPWR VPWR sky130_fd_sc_hd__decap_3
XFILLER_32_158 VGND VGND VPWR VPWR sky130_fd_sc_hd__decap_3
XFILLER_20_309 VGND VGND VPWR VPWR sky130_fd_sc_hd__decap_3
X_2620_ _2620_/A _2620_/B VGND VGND VPWR VPWR _2620_/Y sky130_fd_sc_hd__xnor2_1
X_2551_ _2554_/A _2564_/A VGND VGND VPWR VPWR _2580_/A sky130_fd_sc_hd__or2_1
X_1502_ _1517_/A _1502_/B VGND VGND VPWR VPWR _1506_/C sky130_fd_sc_hd__nand2_1
X_2482_ _2483_/A _2566_/A VGND VGND VPWR VPWR _2482_/X sky130_fd_sc_hd__and2b_1
X_1433_ _1809_/A _2283_/A _1408_/B VGND VGND VPWR VPWR _1671_/A sky130_fd_sc_hd__o21ai_4
XFILLER_49_3 VGND VGND VPWR VPWR sky130_fd_sc_hd__decap_3
XFILLER_55_228 VGND VGND VPWR VPWR sky130_fd_sc_hd__decap_3
XFILLER_55_217 VGND VGND VPWR VPWR sky130_fd_sc_hd__decap_3
XFILLER_23_147 VGND VGND VPWR VPWR sky130_fd_sc_hd__decap_3
XFILLER_31_180 VGND VGND VPWR VPWR sky130_fd_sc_hd__decap_3
X_2749_ _2770_/Q _2749_/B VGND VGND VPWR VPWR _2770_/D sky130_fd_sc_hd__xnor2_1
XFILLER_2_9 VGND VGND VPWR VPWR sky130_fd_sc_hd__decap_3
XFILLER_46_228 VGND VGND VPWR VPWR sky130_fd_sc_hd__decap_3
XFILLER_36_55 VGND VGND VPWR VPWR sky130_fd_sc_hd__decap_3
XFILLER_54_261 VGND VGND VPWR VPWR sky130_fd_sc_hd__decap_3
XFILLER_54_250 VGND VGND VPWR VPWR sky130_fd_sc_hd__fill_2
XFILLER_36_88 VGND VGND VPWR VPWR sky130_fd_sc_hd__decap_3
XFILLER_14_125 VGND VGND VPWR VPWR sky130_fd_sc_hd__decap_3
XFILLER_54_294 VGND VGND VPWR VPWR sky130_fd_sc_hd__decap_3
XFILLER_14_147 VGND VGND VPWR VPWR sky130_fd_sc_hd__decap_3
XTAP_TAPCELL_ROW_52_440 VGND VPWR sky130_fd_sc_hd__tapvpwrvgnd_1
XFILLER_52_21 VGND VGND VPWR VPWR sky130_fd_sc_hd__decap_3
XFILLER_52_54 VGND VGND VPWR VPWR sky130_fd_sc_hd__fill_2
XFILLER_52_98 VGND VGND VPWR VPWR sky130_fd_sc_hd__decap_3
XFILLER_6_357 VGND VGND VPWR VPWR sky130_fd_sc_hd__decap_3
XTAP_TAPCELL_ROW_9_184 VGND VPWR sky130_fd_sc_hd__tapvpwrvgnd_1
XFILLER_35_9 VGND VGND VPWR VPWR sky130_fd_sc_hd__decap_3
XFILLER_45_250 VGND VGND VPWR VPWR sky130_fd_sc_hd__decap_3
XFILLER_60_231 VGND VGND VPWR VPWR sky130_fd_sc_hd__decap_3
XFILLER_60_253 VGND VGND VPWR VPWR sky130_fd_sc_hd__decap_3
X_1982_ _1982_/A _1982_/B VGND VGND VPWR VPWR _1984_/B sky130_fd_sc_hd__xor2_1
XFILLER_9_173 VGND VGND VPWR VPWR sky130_fd_sc_hd__fill_2
X_2603_ _2603_/A _2603_/B VGND VGND VPWR VPWR _2660_/B sky130_fd_sc_hd__or2_1
X_2534_ _2534_/A _2534_/B VGND VGND VPWR VPWR _2636_/B sky130_fd_sc_hd__and2_1
X_2465_ input3/X input4/X VGND VGND VPWR VPWR _2719_/B sky130_fd_sc_hd__and2b_4
X_1416_ _2767_/Q _2768_/Q _1438_/B _1416_/D VGND VGND VPWR VPWR _1416_/X sky130_fd_sc_hd__or4_2
X_2396_ input9/X _2490_/B VGND VGND VPWR VPWR _2397_/B sky130_fd_sc_hd__nor2_1
XFILLER_3_92 VGND VGND VPWR VPWR sky130_fd_sc_hd__decap_3
XFILLER_28_239 VGND VGND VPWR VPWR sky130_fd_sc_hd__decap_3
XFILLER_28_206 VGND VGND VPWR VPWR sky130_fd_sc_hd__decap_3
XFILLER_36_294 VGND VGND VPWR VPWR sky130_fd_sc_hd__fill_2
XFILLER_51_264 VGND VGND VPWR VPWR sky130_fd_sc_hd__decap_3
XFILLER_51_242 VGND VGND VPWR VPWR sky130_fd_sc_hd__fill_1
XFILLER_22_57 VGND VGND VPWR VPWR sky130_fd_sc_hd__decap_3
XFILLER_3_327 VGND VGND VPWR VPWR sky130_fd_sc_hd__decap_3
XFILLER_3_305 VGND VGND VPWR VPWR sky130_fd_sc_hd__decap_3
XFILLER_0_6 VGND VGND VPWR VPWR sky130_fd_sc_hd__decap_3
XFILLER_3_349 VGND VGND VPWR VPWR sky130_fd_sc_hd__decap_3
XFILLER_59_320 VGND VGND VPWR VPWR sky130_fd_sc_hd__decap_3
XTAP_TAPCELL_ROW_6_165 VGND VPWR sky130_fd_sc_hd__tapvpwrvgnd_1
XFILLER_47_21 VGND VGND VPWR VPWR sky130_fd_sc_hd__decap_3
XFILLER_19_228 VGND VGND VPWR VPWR sky130_fd_sc_hd__decap_3
XFILLER_47_76 VGND VGND VPWR VPWR sky130_fd_sc_hd__decap_3
XFILLER_42_264 VGND VGND VPWR VPWR sky130_fd_sc_hd__decap_3
XFILLER_42_253 VGND VGND VPWR VPWR sky130_fd_sc_hd__fill_1
XFILLER_8_15 VGND VGND VPWR VPWR sky130_fd_sc_hd__decap_3
XFILLER_8_59 VGND VGND VPWR VPWR sky130_fd_sc_hd__decap_3
XFILLER_6_132 VGND VGND VPWR VPWR sky130_fd_sc_hd__decap_3
X_2250_ _2250_/A _2250_/B VGND VGND VPWR VPWR _2252_/B sky130_fd_sc_hd__xnor2_1
XFILLER_33_6 VGND VGND VPWR VPWR sky130_fd_sc_hd__decap_3
X_2181_ _2181_/A _2181_/B VGND VGND VPWR VPWR _2196_/A sky130_fd_sc_hd__xor2_1
XFILLER_33_231 VGND VGND VPWR VPWR sky130_fd_sc_hd__decap_3
X_1965_ _1965_/A _1965_/B VGND VGND VPWR VPWR _1967_/C sky130_fd_sc_hd__xnor2_1
X_1896_ _1896_/A _1896_/B VGND VGND VPWR VPWR _1982_/A sky130_fd_sc_hd__xor2_2
XFILLER_0_319 VGND VGND VPWR VPWR sky130_fd_sc_hd__decap_3
X_2517_ _2521_/A _2518_/B VGND VGND VPWR VPWR _2643_/C sky130_fd_sc_hd__nand2_1
X_2448_ _2776_/Q _2448_/B VGND VGND VPWR VPWR _2449_/B sky130_fd_sc_hd__or2_1
X_2379_ _2379_/A _2383_/A VGND VGND VPWR VPWR _2380_/B sky130_fd_sc_hd__or2_1
XFILLER_56_312 VGND VGND VPWR VPWR sky130_fd_sc_hd__decap_3
XFILLER_56_301 VGND VGND VPWR VPWR sky130_fd_sc_hd__decap_3
XTAP_TAPCELL_ROW_3_146 VGND VPWR sky130_fd_sc_hd__tapvpwrvgnd_1
XFILLER_56_345 VGND VGND VPWR VPWR sky130_fd_sc_hd__decap_3
XFILLER_16_209 VGND VGND VPWR VPWR sky130_fd_sc_hd__decap_3
XFILLER_24_220 VGND VGND VPWR VPWR sky130_fd_sc_hd__decap_3
XFILLER_24_242 VGND VGND VPWR VPWR sky130_fd_sc_hd__decap_3
XFILLER_33_12 VGND VGND VPWR VPWR sky130_fd_sc_hd__decap_3
XFILLER_24_275 VGND VGND VPWR VPWR sky130_fd_sc_hd__decap_3
XFILLER_3_113 VGND VGND VPWR VPWR sky130_fd_sc_hd__decap_3
XFILLER_58_53 VGND VGND VPWR VPWR sky130_fd_sc_hd__decap_3
XFILLER_59_150 VGND VGND VPWR VPWR sky130_fd_sc_hd__decap_3
XFILLER_47_323 VGND VGND VPWR VPWR sky130_fd_sc_hd__decap_3
XFILLER_15_231 VGND VGND VPWR VPWR sky130_fd_sc_hd__decap_3
XTAP_TAPCELL_ROW_25_281 VGND VPWR sky130_fd_sc_hd__tapvpwrvgnd_1
X_1750_ _1743_/X _1748_/X _1749_/Y VGND VGND VPWR VPWR _1751_/B sky130_fd_sc_hd__o21a_1
XFILLER_30_256 VGND VGND VPWR VPWR sky130_fd_sc_hd__decap_3
X_1681_ _2057_/A _1681_/B VGND VGND VPWR VPWR _1682_/B sky130_fd_sc_hd__nor2_1
X_2302_ _2295_/B _2297_/B _2300_/Y _2301_/X VGND VGND VPWR VPWR _2303_/B sky130_fd_sc_hd__a211o_1
XFILLER_31_3 VGND VGND VPWR VPWR sky130_fd_sc_hd__decap_3
X_2233_ _2233_/A _2233_/B VGND VGND VPWR VPWR _2248_/B sky130_fd_sc_hd__xor2_1
XFILLER_38_301 VGND VGND VPWR VPWR sky130_fd_sc_hd__decap_3
X_2164_ _2203_/A _2164_/B VGND VGND VPWR VPWR _2197_/B sky130_fd_sc_hd__xnor2_1
XTAP_TAPCELL_ROW_0_127 VGND VPWR sky130_fd_sc_hd__tapvpwrvgnd_1
X_2095_ _2160_/A _2095_/B VGND VGND VPWR VPWR _2096_/B sky130_fd_sc_hd__and2_1
XFILLER_53_337 VGND VGND VPWR VPWR sky130_fd_sc_hd__decap_3
XFILLER_53_326 VGND VGND VPWR VPWR sky130_fd_sc_hd__decap_3
XFILLER_0_82 VGND VGND VPWR VPWR sky130_fd_sc_hd__fill_2
XFILLER_21_278 VGND VGND VPWR VPWR sky130_fd_sc_hd__fill_2
XFILLER_21_256 VGND VGND VPWR VPWR sky130_fd_sc_hd__decap_3
X_1948_ _2249_/B _1886_/B _1582_/A _1656_/A VGND VGND VPWR VPWR _1949_/B sky130_fd_sc_hd__o22a_1
XFILLER_21_289 VGND VGND VPWR VPWR sky130_fd_sc_hd__decap_3
X_1879_ _1398_/Y _1415_/Y _1416_/X _2310_/B VGND VGND VPWR VPWR _1947_/A sky130_fd_sc_hd__o211a_1
XFILLER_0_116 VGND VGND VPWR VPWR sky130_fd_sc_hd__decap_3
XFILLER_48_109 VGND VGND VPWR VPWR sky130_fd_sc_hd__decap_3
XFILLER_56_131 VGND VGND VPWR VPWR sky130_fd_sc_hd__decap_3
XTAP_TAPCELL_ROW_39_362 VGND VPWR sky130_fd_sc_hd__tapvpwrvgnd_1
XFILLER_56_197 VGND VGND VPWR VPWR sky130_fd_sc_hd__decap_3
XFILLER_44_44 VGND VGND VPWR VPWR sky130_fd_sc_hd__decap_3
XFILLER_44_359 VGND VGND VPWR VPWR sky130_fd_sc_hd__fill_2
XFILLER_12_212 VGND VGND VPWR VPWR sky130_fd_sc_hd__decap_3
XFILLER_44_77 VGND VGND VPWR VPWR sky130_fd_sc_hd__decap_3
XFILLER_12_234 VGND VGND VPWR VPWR sky130_fd_sc_hd__decap_3
XFILLER_44_88 VGND VGND VPWR VPWR sky130_fd_sc_hd__decap_3
XFILLER_12_278 VGND VGND VPWR VPWR sky130_fd_sc_hd__decap_3
XFILLER_60_21 VGND VGND VPWR VPWR sky130_fd_sc_hd__decap_3
XTAP_TAPCELL_ROW_22_262 VGND VPWR sky130_fd_sc_hd__tapvpwrvgnd_1
XFILLER_60_32 VGND VGND VPWR VPWR sky130_fd_sc_hd__decap_3
XFILLER_5_27 VGND VGND VPWR VPWR sky130_fd_sc_hd__decap_3
XFILLER_47_197 VGND VGND VPWR VPWR sky130_fd_sc_hd__decap_3
XFILLER_50_318 VGND VGND VPWR VPWR sky130_fd_sc_hd__decap_3
XFILLER_50_307 VGND VGND VPWR VPWR sky130_fd_sc_hd__fill_1
XTAP_TAPCELL_ROW_45_398 VGND VPWR sky130_fd_sc_hd__tapvpwrvgnd_1
X_1802_ _1803_/A _1803_/B VGND VGND VPWR VPWR _1807_/A sky130_fd_sc_hd__nor2_1
X_1733_ _2217_/A _2770_/Q VGND VGND VPWR VPWR _2116_/C sky130_fd_sc_hd__nand2_1
XFILLER_7_260 VGND VGND VPWR VPWR sky130_fd_sc_hd__decap_3
X_1664_ _1624_/B _1805_/S _1664_/S VGND VGND VPWR VPWR _1666_/B sky130_fd_sc_hd__mux2_1
X_1595_ _1596_/A _1771_/A _1776_/A VGND VGND VPWR VPWR _1776_/B sky130_fd_sc_hd__or3b_1
X_2216_ _2336_/A _2214_/X _2726_/A _2264_/A VGND VGND VPWR VPWR _2262_/A sky130_fd_sc_hd__o2bb2a_1
XFILLER_26_304 VGND VGND VPWR VPWR sky130_fd_sc_hd__decap_3
X_2147_ _2732_/A _2199_/B VGND VGND VPWR VPWR _2286_/B sky130_fd_sc_hd__nand2_2
XFILLER_53_101 VGND VGND VPWR VPWR sky130_fd_sc_hd__decap_3
XFILLER_26_315 VGND VGND VPWR VPWR sky130_fd_sc_hd__decap_3
X_2078_ _2372_/A _2078_/B VGND VGND VPWR VPWR _2079_/B sky130_fd_sc_hd__or2_1
XFILLER_53_156 VGND VGND VPWR VPWR sky130_fd_sc_hd__decap_3
XFILLER_26_359 VGND VGND VPWR VPWR sky130_fd_sc_hd__fill_2
XFILLER_53_178 VGND VGND VPWR VPWR sky130_fd_sc_hd__fill_1
XFILLER_14_69 VGND VGND VPWR VPWR sky130_fd_sc_hd__decap_3
XFILLER_14_47 VGND VGND VPWR VPWR sky130_fd_sc_hd__decap_3
XFILLER_5_219 VGND VGND VPWR VPWR sky130_fd_sc_hd__decap_3
XFILLER_30_24 VGND VGND VPWR VPWR sky130_fd_sc_hd__decap_3
XFILLER_29_131 VGND VGND VPWR VPWR sky130_fd_sc_hd__decap_3
XFILLER_55_21 VGND VGND VPWR VPWR sky130_fd_sc_hd__decap_3
XFILLER_29_197 VGND VGND VPWR VPWR sky130_fd_sc_hd__decap_3
XFILLER_29_164 VGND VGND VPWR VPWR sky130_fd_sc_hd__decap_3
XFILLER_17_337 VGND VGND VPWR VPWR sky130_fd_sc_hd__fill_2
XFILLER_55_76 VGND VGND VPWR VPWR sky130_fd_sc_hd__decap_3
XFILLER_32_329 VGND VGND VPWR VPWR sky130_fd_sc_hd__decap_3
XFILLER_32_318 VGND VGND VPWR VPWR sky130_fd_sc_hd__decap_3
X_1380_ _2770_/Q VGND VGND VPWR VPWR _2206_/A sky130_fd_sc_hd__inv_2
X_2001_ _1998_/B _2062_/B _1998_/A VGND VGND VPWR VPWR _2007_/A sky130_fd_sc_hd__o21ba_1
XFILLER_35_101 VGND VGND VPWR VPWR sky130_fd_sc_hd__decap_3
XFILLER_35_145 VGND VGND VPWR VPWR sky130_fd_sc_hd__decap_3
XFILLER_35_134 VGND VGND VPWR VPWR sky130_fd_sc_hd__decap_3
XFILLER_35_178 VGND VGND VPWR VPWR sky130_fd_sc_hd__decap_3
XFILLER_50_137 VGND VGND VPWR VPWR sky130_fd_sc_hd__decap_3
XFILLER_31_340 VGND VGND VPWR VPWR sky130_fd_sc_hd__fill_2
X_2765_ clkload0/A _2765_/D fanout47/X VGND VGND VPWR VPWR _2765_/Q sky130_fd_sc_hd__dfrtp_4
X_1716_ _1696_/A _1696_/B _1697_/X VGND VGND VPWR VPWR _1720_/A sky130_fd_sc_hd__o21bai_1
X_2696_ _2696_/A _2696_/B VGND VGND VPWR VPWR _2696_/X sky130_fd_sc_hd__and2_1
XFILLER_6_70 VGND VGND VPWR VPWR sky130_fd_sc_hd__fill_2
X_1647_ _1647_/A _1647_/B VGND VGND VPWR VPWR _1723_/B sky130_fd_sc_hd__xnor2_1
X_1578_ _1587_/A _1573_/Y _1577_/X VGND VGND VPWR VPWR _1579_/B sky130_fd_sc_hd__o21ai_1
XFILLER_58_237 VGND VGND VPWR VPWR sky130_fd_sc_hd__decap_3
XFILLER_58_259 VGND VGND VPWR VPWR sky130_fd_sc_hd__decap_3
XFILLER_26_112 VGND VGND VPWR VPWR sky130_fd_sc_hd__fill_2
XFILLER_26_123 VGND VGND VPWR VPWR sky130_fd_sc_hd__decap_3
XFILLER_26_178 VGND VGND VPWR VPWR sky130_fd_sc_hd__fill_1
XFILLER_26_156 VGND VGND VPWR VPWR sky130_fd_sc_hd__decap_3
XFILLER_25_24 VGND VGND VPWR VPWR sky130_fd_sc_hd__decap_3
XFILLER_14_307 VGND VGND VPWR VPWR sky130_fd_sc_hd__fill_1
XFILLER_41_148 VGND VGND VPWR VPWR sky130_fd_sc_hd__fill_2
XFILLER_41_137 VGND VGND VPWR VPWR sky130_fd_sc_hd__fill_1
XFILLER_41_12 VGND VGND VPWR VPWR sky130_fd_sc_hd__decap_3
XPHY_EDGE_ROW_38_Left_99 VGND VGND VPWR VPWR sky130_fd_sc_hd__decap_3
XFILLER_41_78 VGND VGND VPWR VPWR sky130_fd_sc_hd__decap_3
XFILLER_9_3 VGND VGND VPWR VPWR sky130_fd_sc_hd__decap_3
XFILLER_1_222 VGND VGND VPWR VPWR sky130_fd_sc_hd__fill_2
XFILLER_49_237 VGND VGND VPWR VPWR sky130_fd_sc_hd__fill_1
XFILLER_57_281 VGND VGND VPWR VPWR sky130_fd_sc_hd__decap_3
XFILLER_57_270 VGND VGND VPWR VPWR sky130_fd_sc_hd__decap_3
XFILLER_17_101 VGND VGND VPWR VPWR sky130_fd_sc_hd__fill_2
XTAP_TAPCELL_ROW_55_460 VGND VPWR sky130_fd_sc_hd__tapvpwrvgnd_1
XFILLER_17_167 VGND VGND VPWR VPWR sky130_fd_sc_hd__fill_1
XFILLER_17_156 VGND VGND VPWR VPWR sky130_fd_sc_hd__fill_2
XFILLER_13_340 VGND VGND VPWR VPWR sky130_fd_sc_hd__fill_1
XFILLER_40_181 VGND VGND VPWR VPWR sky130_fd_sc_hd__decap_3
X_2550_ _2550_/A _2550_/B VGND VGND VPWR VPWR _2564_/A sky130_fd_sc_hd__xnor2_2
X_1501_ _1704_/B _2356_/A _2219_/B _2057_/A VGND VGND VPWR VPWR _1501_/X sky130_fd_sc_hd__a31o_1
X_2481_ _2490_/B _2483_/A VGND VGND VPWR VPWR _2555_/A sky130_fd_sc_hd__xor2_2
X_1432_ _2765_/Q _2335_/B VGND VGND VPWR VPWR _2283_/A sky130_fd_sc_hd__nand2_2
XFILLER_48_281 VGND VGND VPWR VPWR sky130_fd_sc_hd__decap_3
XFILLER_23_126 VGND VGND VPWR VPWR sky130_fd_sc_hd__decap_3
XFILLER_23_159 VGND VGND VPWR VPWR sky130_fd_sc_hd__decap_3
XFILLER_31_192 VGND VGND VPWR VPWR sky130_fd_sc_hd__decap_3
XFILLER_11_37 VGND VGND VPWR VPWR sky130_fd_sc_hd__decap_3
X_2748_ hold1/X _2748_/B VGND VGND VPWR VPWR _2769_/D sky130_fd_sc_hd__xor2_1
X_2679_ _2616_/Y _2618_/Y _2719_/B VGND VGND VPWR VPWR _2679_/Y sky130_fd_sc_hd__o21ai_1
XFILLER_46_207 VGND VGND VPWR VPWR sky130_fd_sc_hd__decap_3
XFILLER_36_12 VGND VGND VPWR VPWR sky130_fd_sc_hd__decap_3
XFILLER_39_281 VGND VGND VPWR VPWR sky130_fd_sc_hd__decap_3
XFILLER_14_104 VGND VGND VPWR VPWR sky130_fd_sc_hd__decap_3
XFILLER_36_67 VGND VGND VPWR VPWR sky130_fd_sc_hd__decap_3
XFILLER_54_273 VGND VGND VPWR VPWR sky130_fd_sc_hd__decap_3
XTAP_TAPCELL_ROW_52_441 VGND VPWR sky130_fd_sc_hd__tapvpwrvgnd_1
XFILLER_6_325 VGND VGND VPWR VPWR sky130_fd_sc_hd__decap_3
XTAP_TAPCELL_ROW_9_185 VGND VPWR sky130_fd_sc_hd__tapvpwrvgnd_1
XFILLER_60_221 VGND VGND VPWR VPWR sky130_fd_sc_hd__decap_3
XFILLER_45_284 VGND VGND VPWR VPWR sky130_fd_sc_hd__fill_2
XFILLER_45_273 VGND VGND VPWR VPWR sky130_fd_sc_hd__decap_3
XFILLER_60_265 VGND VGND VPWR VPWR sky130_fd_sc_hd__decap_3
XFILLER_60_243 VGND VGND VPWR VPWR sky130_fd_sc_hd__decap_3
X_1981_ _1981_/A _1981_/B VGND VGND VPWR VPWR _1984_/A sky130_fd_sc_hd__or2_1
XFILLER_60_287 VGND VGND VPWR VPWR sky130_fd_sc_hd__decap_3
XFILLER_13_192 VGND VGND VPWR VPWR sky130_fd_sc_hd__fill_1
XFILLER_9_185 VGND VGND VPWR VPWR sky130_fd_sc_hd__decap_3
X_2602_ _2602_/A _2636_/A _2602_/C VGND VGND VPWR VPWR _2603_/B sky130_fd_sc_hd__nor3_1
X_2533_ _2534_/A _2534_/B VGND VGND VPWR VPWR _2636_/A sky130_fd_sc_hd__nor2_1
X_2464_ _2669_/A _2464_/B VGND VGND VPWR VPWR _2468_/A sky130_fd_sc_hd__nor2_1
X_1415_ _2768_/Q _1438_/B VGND VGND VPWR VPWR _1415_/Y sky130_fd_sc_hd__xnor2_2
X_2395_ input9/X _2490_/B VGND VGND VPWR VPWR _2431_/A sky130_fd_sc_hd__and2_1
XFILLER_3_71 VGND VGND VPWR VPWR sky130_fd_sc_hd__decap_3
XFILLER_3_60 VGND VGND VPWR VPWR sky130_fd_sc_hd__fill_2
XFILLER_36_262 VGND VGND VPWR VPWR sky130_fd_sc_hd__decap_3
XFILLER_36_240 VGND VGND VPWR VPWR sky130_fd_sc_hd__decap_3
XFILLER_11_129 VGND VGND VPWR VPWR sky130_fd_sc_hd__decap_3
XFILLER_51_287 VGND VGND VPWR VPWR sky130_fd_sc_hd__decap_3
XFILLER_51_276 VGND VGND VPWR VPWR sky130_fd_sc_hd__decap_3
XTAP_TAPCELL_ROW_6_166 VGND VPWR sky130_fd_sc_hd__tapvpwrvgnd_1
XFILLER_59_343 VGND VGND VPWR VPWR sky130_fd_sc_hd__decap_3
XFILLER_59_332 VGND VGND VPWR VPWR sky130_fd_sc_hd__decap_3
XFILLER_47_55 VGND VGND VPWR VPWR sky130_fd_sc_hd__fill_1
XFILLER_47_33 VGND VGND VPWR VPWR sky130_fd_sc_hd__decap_3
XFILLER_42_221 VGND VGND VPWR VPWR sky130_fd_sc_hd__decap_3
XFILLER_42_210 VGND VGND VPWR VPWR sky130_fd_sc_hd__decap_3
XFILLER_27_284 VGND VGND VPWR VPWR sky130_fd_sc_hd__decap_3
XFILLER_42_243 VGND VGND VPWR VPWR sky130_fd_sc_hd__decap_3
XFILLER_8_38 VGND VGND VPWR VPWR sky130_fd_sc_hd__decap_3
XFILLER_8_27 VGND VGND VPWR VPWR sky130_fd_sc_hd__fill_1
XFILLER_6_144 VGND VGND VPWR VPWR sky130_fd_sc_hd__decap_3
XFILLER_6_111 VGND VGND VPWR VPWR sky130_fd_sc_hd__fill_1
XFILLER_12_80 VGND VGND VPWR VPWR sky130_fd_sc_hd__decap_3
XFILLER_12_91 VGND VGND VPWR VPWR sky130_fd_sc_hd__decap_3
X_2180_ _2181_/B _2181_/A VGND VGND VPWR VPWR _2180_/Y sky130_fd_sc_hd__nand2b_1
XPHY_EDGE_ROW_25_Left_86 VGND VGND VPWR VPWR sky130_fd_sc_hd__decap_3
XFILLER_33_221 VGND VGND VPWR VPWR sky130_fd_sc_hd__decap_3
XFILLER_33_287 VGND VGND VPWR VPWR sky130_fd_sc_hd__fill_2
X_1964_ _2029_/A _2029_/B VGND VGND VPWR VPWR _1967_/B sky130_fd_sc_hd__nand2_1
X_1895_ _1896_/B _1896_/A VGND VGND VPWR VPWR _1915_/A sky130_fd_sc_hd__and2b_1
XFILLER_0_309 VGND VGND VPWR VPWR sky130_fd_sc_hd__fill_1
X_2516_ _2507_/A _2527_/A _2657_/A VGND VGND VPWR VPWR _2518_/B sky130_fd_sc_hd__mux2_1
X_2447_ _2687_/A _2687_/B VGND VGND VPWR VPWR _2694_/B sky130_fd_sc_hd__nand2b_1
X_2378_ _2657_/A VGND VGND VPWR VPWR _2643_/A sky130_fd_sc_hd__inv_2
XTAP_TAPCELL_ROW_3_147 VGND VPWR sky130_fd_sc_hd__tapvpwrvgnd_1
XFILLER_56_324 VGND VGND VPWR VPWR sky130_fd_sc_hd__decap_3
XFILLER_56_357 VGND VGND VPWR VPWR sky130_fd_sc_hd__decap_3
XFILLER_17_47 VGND VGND VPWR VPWR sky130_fd_sc_hd__decap_3
XFILLER_33_57 VGND VGND VPWR VPWR sky130_fd_sc_hd__decap_3
XFILLER_3_169 VGND VGND VPWR VPWR sky130_fd_sc_hd__decap_3
XFILLER_3_136 VGND VGND VPWR VPWR sky130_fd_sc_hd__decap_3
XFILLER_58_21 VGND VGND VPWR VPWR sky130_fd_sc_hd__decap_3
XFILLER_58_65 VGND VGND VPWR VPWR sky130_fd_sc_hd__decap_3
XFILLER_58_32 VGND VGND VPWR VPWR sky130_fd_sc_hd__decap_3
XFILLER_47_346 VGND VGND VPWR VPWR sky130_fd_sc_hd__decap_3
XFILLER_47_335 VGND VGND VPWR VPWR sky130_fd_sc_hd__fill_1
XFILLER_15_210 VGND VGND VPWR VPWR sky130_fd_sc_hd__decap_3
XFILLER_15_243 VGND VGND VPWR VPWR sky130_fd_sc_hd__decap_3
XFILLER_15_265 VGND VGND VPWR VPWR sky130_fd_sc_hd__decap_3
XTAP_TAPCELL_ROW_25_282 VGND VPWR sky130_fd_sc_hd__tapvpwrvgnd_1
XFILLER_30_224 VGND VGND VPWR VPWR sky130_fd_sc_hd__decap_3
XFILLER_30_268 VGND VGND VPWR VPWR sky130_fd_sc_hd__decap_3
XFILLER_23_90 VGND VGND VPWR VPWR sky130_fd_sc_hd__decap_3
X_1680_ _1824_/A _1824_/B _1679_/A VGND VGND VPWR VPWR _1684_/A sky130_fd_sc_hd__a21o_1
X_2301_ _2272_/B _2299_/X _2298_/Y _2289_/Y VGND VGND VPWR VPWR _2301_/X sky130_fd_sc_hd__o211a_1
X_2232_ _2232_/A _2232_/B VGND VGND VPWR VPWR _2248_/A sky130_fd_sc_hd__xnor2_1
XFILLER_24_3 VGND VGND VPWR VPWR sky130_fd_sc_hd__fill_2
X_2163_ _2163_/A _2163_/B VGND VGND VPWR VPWR _2197_/A sky130_fd_sc_hd__xnor2_1
XFILLER_38_335 VGND VGND VPWR VPWR sky130_fd_sc_hd__fill_2
XFILLER_38_324 VGND VGND VPWR VPWR sky130_fd_sc_hd__decap_3
XFILLER_53_305 VGND VGND VPWR VPWR sky130_fd_sc_hd__decap_3
XFILLER_0_50 VGND VGND VPWR VPWR sky130_fd_sc_hd__decap_3
XFILLER_0_61 VGND VGND VPWR VPWR sky130_fd_sc_hd__decap_3
X_2094_ _2094_/A _2094_/B VGND VGND VPWR VPWR _2153_/A sky130_fd_sc_hd__xnor2_1
XTAP_TAPCELL_ROW_0_128 VGND VPWR sky130_fd_sc_hd__tapvpwrvgnd_1
XFILLER_53_349 VGND VGND VPWR VPWR sky130_fd_sc_hd__decap_3
XFILLER_21_202 VGND VGND VPWR VPWR sky130_fd_sc_hd__decap_3
XFILLER_9_81 VGND VGND VPWR VPWR sky130_fd_sc_hd__decap_3
X_1947_ _1947_/A _1947_/B VGND VGND VPWR VPWR _1949_/A sky130_fd_sc_hd__and2_1
X_1878_ _1878_/A _1886_/A _1878_/C _2283_/B VGND VGND VPWR VPWR _1881_/A sky130_fd_sc_hd__or4_1
XFILLER_0_128 VGND VGND VPWR VPWR sky130_fd_sc_hd__decap_3
XFILLER_29_302 VGND VGND VPWR VPWR sky130_fd_sc_hd__decap_3
XFILLER_56_110 VGND VGND VPWR VPWR sky130_fd_sc_hd__decap_3
XFILLER_29_324 VGND VGND VPWR VPWR sky130_fd_sc_hd__decap_3
XFILLER_28_57 VGND VGND VPWR VPWR sky130_fd_sc_hd__decap_3
XFILLER_28_35 VGND VGND VPWR VPWR sky130_fd_sc_hd__fill_1
XFILLER_56_165 VGND VGND VPWR VPWR sky130_fd_sc_hd__decap_3
XFILLER_44_305 VGND VGND VPWR VPWR sky130_fd_sc_hd__decap_3
XFILLER_29_357 VGND VGND VPWR VPWR sky130_fd_sc_hd__decap_3
XFILLER_28_79 VGND VGND VPWR VPWR sky130_fd_sc_hd__decap_3
XTAP_TAPCELL_ROW_39_363 VGND VPWR sky130_fd_sc_hd__tapvpwrvgnd_1
XFILLER_56_187 VGND VGND VPWR VPWR sky130_fd_sc_hd__decap_3
XFILLER_44_338 VGND VGND VPWR VPWR sky130_fd_sc_hd__decap_3
XFILLER_44_316 VGND VGND VPWR VPWR sky130_fd_sc_hd__decap_3
XFILLER_44_12 VGND VGND VPWR VPWR sky130_fd_sc_hd__decap_3
XFILLER_52_360 VGND VGND VPWR VPWR sky130_fd_sc_hd__fill_1
XFILLER_44_56 VGND VGND VPWR VPWR sky130_fd_sc_hd__decap_3
XFILLER_8_206 VGND VGND VPWR VPWR sky130_fd_sc_hd__decap_3
XTAP_TAPCELL_ROW_22_263 VGND VPWR sky130_fd_sc_hd__tapvpwrvgnd_1
XFILLER_60_44 VGND VGND VPWR VPWR sky130_fd_sc_hd__decap_3
XFILLER_60_88 VGND VGND VPWR VPWR sky130_fd_sc_hd__decap_3
XFILLER_60_66 VGND VGND VPWR VPWR sky130_fd_sc_hd__decap_3
XFILLER_5_39 VGND VGND VPWR VPWR sky130_fd_sc_hd__decap_3
XFILLER_35_316 VGND VGND VPWR VPWR sky130_fd_sc_hd__fill_1
XFILLER_43_360 VGND VGND VPWR VPWR sky130_fd_sc_hd__fill_1
XTAP_TAPCELL_ROW_45_399 VGND VPWR sky130_fd_sc_hd__tapvpwrvgnd_1
X_1801_ _1801_/A _1801_/B VGND VGND VPWR VPWR _1803_/B sky130_fd_sc_hd__xor2_1
X_1732_ _1898_/A _2206_/A VGND VGND VPWR VPWR _2356_/B sky130_fd_sc_hd__nor2_1
X_1663_ _1663_/A _1809_/A VGND VGND VPWR VPWR _1664_/S sky130_fd_sc_hd__nor2_1
X_1594_ _1771_/A _1776_/A VGND VGND VPWR VPWR _1596_/B sky130_fd_sc_hd__and2b_1
XPHY_EDGE_ROW_7_Right_7 VGND VGND VPWR VPWR sky130_fd_sc_hd__decap_3
X_2215_ _2264_/A _2726_/A VGND VGND VPWR VPWR _2265_/A sky130_fd_sc_hd__nor2_1
XFILLER_38_121 VGND VGND VPWR VPWR sky130_fd_sc_hd__decap_3
XFILLER_38_154 VGND VGND VPWR VPWR sky130_fd_sc_hd__decap_3
X_2146_ _2146_/A _2146_/B VGND VGND VPWR VPWR _2152_/A sky130_fd_sc_hd__xnor2_1
XFILLER_53_113 VGND VGND VPWR VPWR sky130_fd_sc_hd__fill_1
XFILLER_38_176 VGND VGND VPWR VPWR sky130_fd_sc_hd__decap_3
XFILLER_26_327 VGND VGND VPWR VPWR sky130_fd_sc_hd__decap_3
X_2077_ _2077_/A _2077_/B _2077_/C VGND VGND VPWR VPWR _2078_/B sky130_fd_sc_hd__nor3_1
XTAP_TAPCELL_ROW_36_344 VGND VPWR sky130_fd_sc_hd__tapvpwrvgnd_1
XFILLER_14_59 VGND VGND VPWR VPWR sky130_fd_sc_hd__fill_2
XPHY_EDGE_ROW_12_Left_73 VGND VGND VPWR VPWR sky130_fd_sc_hd__decap_3
XFILLER_39_12 VGND VGND VPWR VPWR sky130_fd_sc_hd__decap_3
XFILLER_39_45 VGND VGND VPWR VPWR sky130_fd_sc_hd__decap_3
XFILLER_55_33 VGND VGND VPWR VPWR sky130_fd_sc_hd__decap_3
XFILLER_17_305 VGND VGND VPWR VPWR sky130_fd_sc_hd__decap_3
XFILLER_44_179 VGND VGND VPWR VPWR sky130_fd_sc_hd__decap_3
XFILLER_58_9 VGND VGND VPWR VPWR sky130_fd_sc_hd__decap_3
XFILLER_4_253 VGND VGND VPWR VPWR sky130_fd_sc_hd__decap_3
X_2000_ _2000_/A _2144_/A VGND VGND VPWR VPWR _2062_/B sky130_fd_sc_hd__nand2_1
XFILLER_35_113 VGND VGND VPWR VPWR sky130_fd_sc_hd__decap_3
XTAP_TAPCELL_ROW_58_480 VGND VPWR sky130_fd_sc_hd__tapvpwrvgnd_1
XFILLER_35_157 VGND VGND VPWR VPWR sky130_fd_sc_hd__decap_3
XFILLER_23_319 VGND VGND VPWR VPWR sky130_fd_sc_hd__decap_3
XFILLER_50_127 VGND VGND VPWR VPWR sky130_fd_sc_hd__decap_3
X_2764_ clkload0/A _2764_/D fanout47/X VGND VGND VPWR VPWR _2764_/Q sky130_fd_sc_hd__dfrtp_4
X_1715_ _2000_/A _1854_/B _1714_/A VGND VGND VPWR VPWR _1721_/A sky130_fd_sc_hd__a21o_1
X_2695_ _2700_/C _2694_/Y _2669_/A VGND VGND VPWR VPWR _2696_/B sky130_fd_sc_hd__a21o_1
X_1646_ _1646_/A _1646_/B VGND VGND VPWR VPWR _1723_/A sky130_fd_sc_hd__xnor2_1
X_1577_ _1586_/A _1414_/X _1582_/A _1606_/A _1581_/S VGND VGND VPWR VPWR _1577_/X
+ sky130_fd_sc_hd__a32o_1
XFILLER_58_249 VGND VGND VPWR VPWR sky130_fd_sc_hd__decap_3
XFILLER_58_216 VGND VGND VPWR VPWR sky130_fd_sc_hd__decap_3
X_2129_ _2129_/A _2129_/B VGND VGND VPWR VPWR _2130_/B sky130_fd_sc_hd__xnor2_1
XFILLER_41_105 VGND VGND VPWR VPWR sky130_fd_sc_hd__decap_3
XFILLER_25_36 VGND VGND VPWR VPWR sky130_fd_sc_hd__decap_3
XFILLER_41_116 VGND VGND VPWR VPWR sky130_fd_sc_hd__decap_3
XFILLER_34_190 VGND VGND VPWR VPWR sky130_fd_sc_hd__decap_3
XFILLER_41_57 VGND VGND VPWR VPWR sky130_fd_sc_hd__decap_3
XFILLER_49_216 VGND VGND VPWR VPWR sky130_fd_sc_hd__decap_3
XFILLER_2_29 VGND VGND VPWR VPWR sky130_fd_sc_hd__decap_3
XFILLER_2_18 VGND VGND VPWR VPWR sky130_fd_sc_hd__decap_3
XFILLER_57_293 VGND VGND VPWR VPWR sky130_fd_sc_hd__decap_3
XFILLER_17_135 VGND VGND VPWR VPWR sky130_fd_sc_hd__decap_3
XTAP_TAPCELL_ROW_55_461 VGND VPWR sky130_fd_sc_hd__tapvpwrvgnd_1
XFILLER_32_105 VGND VGND VPWR VPWR sky130_fd_sc_hd__decap_3
XFILLER_13_330 VGND VGND VPWR VPWR sky130_fd_sc_hd__decap_3
XFILLER_13_352 VGND VGND VPWR VPWR sky130_fd_sc_hd__decap_3
XFILLER_9_301 VGND VGND VPWR VPWR sky130_fd_sc_hd__decap_3
XFILLER_32_149 VGND VGND VPWR VPWR sky130_fd_sc_hd__decap_3
XFILLER_40_160 VGND VGND VPWR VPWR sky130_fd_sc_hd__decap_3
XFILLER_40_193 VGND VGND VPWR VPWR sky130_fd_sc_hd__decap_3
X_1500_ _1820_/B _2356_/A _1499_/B _1498_/Y VGND VGND VPWR VPWR _1711_/A sky130_fd_sc_hd__o31ai_2
X_2480_ _2490_/B _2483_/A VGND VGND VPWR VPWR _2480_/Y sky130_fd_sc_hd__nor2_1
XFILLER_56_6 VGND VGND VPWR VPWR sky130_fd_sc_hd__decap_3
X_1431_ _1434_/B _1434_/C _1813_/A VGND VGND VPWR VPWR _1435_/A sky130_fd_sc_hd__o21a_1
XFILLER_48_293 VGND VGND VPWR VPWR sky130_fd_sc_hd__decap_3
XFILLER_23_105 VGND VGND VPWR VPWR sky130_fd_sc_hd__decap_3
X_2747_ _2747_/A _2748_/B VGND VGND VPWR VPWR _2768_/D sky130_fd_sc_hd__nor2_1
X_2678_ input6/X _2678_/B VGND VGND VPWR VPWR uo_out[0] sky130_fd_sc_hd__xnor2_4
X_1629_ _1629_/A VGND VGND VPWR VPWR _1655_/B sky130_fd_sc_hd__inv_2
XFILLER_46_219 VGND VGND VPWR VPWR sky130_fd_sc_hd__decap_3
XFILLER_39_260 VGND VGND VPWR VPWR sky130_fd_sc_hd__decap_3
XFILLER_36_79 VGND VGND VPWR VPWR sky130_fd_sc_hd__decap_3
XFILLER_14_116 VGND VGND VPWR VPWR sky130_fd_sc_hd__decap_3
XFILLER_54_285 VGND VGND VPWR VPWR sky130_fd_sc_hd__decap_3
XFILLER_14_138 VGND VGND VPWR VPWR sky130_fd_sc_hd__fill_2
XTAP_TAPCELL_ROW_52_442 VGND VPWR sky130_fd_sc_hd__tapvpwrvgnd_1
XFILLER_52_12 VGND VGND VPWR VPWR sky130_fd_sc_hd__decap_3
XFILLER_10_355 VGND VGND VPWR VPWR sky130_fd_sc_hd__decap_3
XFILLER_6_315 VGND VGND VPWR VPWR sky130_fd_sc_hd__decap_3
XFILLER_6_304 VGND VGND VPWR VPWR sky130_fd_sc_hd__decap_3
XFILLER_6_348 VGND VGND VPWR VPWR sky130_fd_sc_hd__decap_3
XTAP_TAPCELL_ROW_9_186 VGND VPWR sky130_fd_sc_hd__tapvpwrvgnd_1
XFILLER_45_241 VGND VGND VPWR VPWR sky130_fd_sc_hd__decap_3
XFILLER_60_200 VGND VGND VPWR VPWR sky130_fd_sc_hd__decap_3
X_1980_ _1981_/A _1980_/B _1980_/C VGND VGND VPWR VPWR _1981_/B sky130_fd_sc_hd__nor3_1
XFILLER_60_277 VGND VGND VPWR VPWR sky130_fd_sc_hd__decap_3
XFILLER_60_299 VGND VGND VPWR VPWR sky130_fd_sc_hd__decap_3
XFILLER_9_164 VGND VGND VPWR VPWR sky130_fd_sc_hd__decap_3
X_2601_ _2660_/A _2601_/B _2601_/C VGND VGND VPWR VPWR _2640_/A sky130_fd_sc_hd__nor3_1
X_2532_ _2532_/A _2541_/A VGND VGND VPWR VPWR _2534_/B sky130_fd_sc_hd__xor2_1
XFILLER_54_3 VGND VGND VPWR VPWR sky130_fd_sc_hd__decap_3
X_2463_ _2463_/A _2656_/B _2662_/B _2662_/C VGND VGND VPWR VPWR _2464_/B sky130_fd_sc_hd__or4_1
X_1414_ _1414_/A _1414_/B VGND VGND VPWR VPWR _1414_/X sky130_fd_sc_hd__and2_1
X_2394_ _2394_/A _2394_/B VGND VGND VPWR VPWR _2490_/B sky130_fd_sc_hd__xnor2_4
XFILLER_3_83 VGND VGND VPWR VPWR sky130_fd_sc_hd__decap_3
XFILLER_51_222 VGND VGND VPWR VPWR sky130_fd_sc_hd__fill_2
XFILLER_36_274 VGND VGND VPWR VPWR sky130_fd_sc_hd__decap_3
XFILLER_51_233 VGND VGND VPWR VPWR sky130_fd_sc_hd__decap_3
XFILLER_11_108 VGND VGND VPWR VPWR sky130_fd_sc_hd__decap_3
XFILLER_51_299 VGND VGND VPWR VPWR sky130_fd_sc_hd__decap_3
XFILLER_22_15 VGND VGND VPWR VPWR sky130_fd_sc_hd__fill_2
XFILLER_59_311 VGND VGND VPWR VPWR sky130_fd_sc_hd__decap_3
XTAP_TAPCELL_ROW_6_167 VGND VPWR sky130_fd_sc_hd__tapvpwrvgnd_1
XFILLER_59_355 VGND VGND VPWR VPWR sky130_fd_sc_hd__decap_3
XFILLER_47_12 VGND VGND VPWR VPWR sky130_fd_sc_hd__decap_3
XFILLER_47_67 VGND VGND VPWR VPWR sky130_fd_sc_hd__decap_3
XFILLER_27_241 VGND VGND VPWR VPWR sky130_fd_sc_hd__fill_2
XFILLER_42_233 VGND VGND VPWR VPWR sky130_fd_sc_hd__decap_3
XFILLER_10_141 VGND VGND VPWR VPWR sky130_fd_sc_hd__fill_1
XFILLER_10_152 VGND VGND VPWR VPWR sky130_fd_sc_hd__fill_2
XFILLER_6_167 VGND VGND VPWR VPWR sky130_fd_sc_hd__decap_3
XFILLER_40_9 VGND VGND VPWR VPWR sky130_fd_sc_hd__decap_3
XPHY_EDGE_ROW_0_Left_61 VGND VGND VPWR VPWR sky130_fd_sc_hd__decap_3
XFILLER_2_351 VGND VGND VPWR VPWR sky130_fd_sc_hd__decap_3
XFILLER_19_6 VGND VGND VPWR VPWR sky130_fd_sc_hd__decap_3
XFILLER_18_241 VGND VGND VPWR VPWR sky130_fd_sc_hd__decap_3
XFILLER_18_285 VGND VGND VPWR VPWR sky130_fd_sc_hd__decap_3
X_1963_ _1963_/A _1963_/B VGND VGND VPWR VPWR _2029_/B sky130_fd_sc_hd__xor2_1
XFILLER_33_299 VGND VGND VPWR VPWR sky130_fd_sc_hd__decap_3
X_1894_ _1894_/A _1894_/B VGND VGND VPWR VPWR _1896_/B sky130_fd_sc_hd__xnor2_1
X_2515_ _2595_/A _2532_/A VGND VGND VPWR VPWR _2521_/A sky130_fd_sc_hd__nor2_1
X_2446_ _2774_/Q _2440_/A _2440_/B _2445_/X VGND VGND VPWR VPWR _2687_/B sky130_fd_sc_hd__a31o_1
X_2377_ _2506_/A _2506_/B VGND VGND VPWR VPWR _2657_/A sky130_fd_sc_hd__nand2_2
XTAP_TAPCELL_ROW_3_148 VGND VPWR sky130_fd_sc_hd__tapvpwrvgnd_1
XFILLER_56_336 VGND VGND VPWR VPWR sky130_fd_sc_hd__decap_3
XFILLER_24_200 VGND VGND VPWR VPWR sky130_fd_sc_hd__decap_3
XFILLER_24_266 VGND VGND VPWR VPWR sky130_fd_sc_hd__decap_3
XFILLER_3_104 VGND VGND VPWR VPWR sky130_fd_sc_hd__decap_3
XFILLER_3_148 VGND VGND VPWR VPWR sky130_fd_sc_hd__decap_3
XFILLER_58_44 VGND VGND VPWR VPWR sky130_fd_sc_hd__decap_3
XFILLER_58_88 VGND VGND VPWR VPWR sky130_fd_sc_hd__decap_3
XFILLER_58_77 VGND VGND VPWR VPWR sky130_fd_sc_hd__decap_3
XFILLER_47_314 VGND VGND VPWR VPWR sky130_fd_sc_hd__decap_3
XFILLER_47_358 VGND VGND VPWR VPWR sky130_fd_sc_hd__decap_3
XFILLER_15_222 VGND VGND VPWR VPWR sky130_fd_sc_hd__fill_2
XFILLER_15_277 VGND VGND VPWR VPWR sky130_fd_sc_hd__decap_3
XTAP_TAPCELL_ROW_25_283 VGND VPWR sky130_fd_sc_hd__tapvpwrvgnd_1
X_2300_ _2289_/Y _2298_/Y _2299_/X _2272_/B VGND VGND VPWR VPWR _2300_/Y sky130_fd_sc_hd__a211oi_1
X_2231_ _2232_/A _2232_/B VGND VGND VPWR VPWR _2237_/B sky130_fd_sc_hd__nand2b_1
X_2162_ _2162_/A _2162_/B VGND VGND VPWR VPWR _2163_/B sky130_fd_sc_hd__xnor2_1
XFILLER_17_3 VGND VGND VPWR VPWR sky130_fd_sc_hd__decap_3
X_2093_ _2094_/B _2094_/A VGND VGND VPWR VPWR _2104_/B sky130_fd_sc_hd__and2b_1
XFILLER_38_358 VGND VGND VPWR VPWR sky130_fd_sc_hd__decap_3
XTAP_TAPCELL_ROW_0_129 VGND VPWR sky130_fd_sc_hd__tapvpwrvgnd_1
XFILLER_53_317 VGND VGND VPWR VPWR sky130_fd_sc_hd__decap_3
XFILLER_0_73 VGND VGND VPWR VPWR sky130_fd_sc_hd__decap_3
XFILLER_0_95 VGND VGND VPWR VPWR sky130_fd_sc_hd__decap_3
XFILLER_21_214 VGND VGND VPWR VPWR sky130_fd_sc_hd__decap_3
XFILLER_9_60 VGND VGND VPWR VPWR sky130_fd_sc_hd__decap_3
X_1946_ _1421_/A _1421_/B _2249_/B VGND VGND VPWR VPWR _1947_/B sky130_fd_sc_hd__a21oi_1
X_1877_ _2249_/B _1886_/A _1799_/C VGND VGND VPWR VPWR _1877_/Y sky130_fd_sc_hd__o21ai_1
X_2429_ _2430_/B VGND VGND VPWR VPWR _2429_/Y sky130_fd_sc_hd__inv_2
XFILLER_56_122 VGND VGND VPWR VPWR sky130_fd_sc_hd__decap_3
XFILLER_28_25 VGND VGND VPWR VPWR sky130_fd_sc_hd__decap_3
XFILLER_56_144 VGND VGND VPWR VPWR sky130_fd_sc_hd__decap_3
XTAP_TAPCELL_ROW_39_364 VGND VPWR sky130_fd_sc_hd__tapvpwrvgnd_1
XFILLER_56_177 VGND VGND VPWR VPWR sky130_fd_sc_hd__decap_3
XFILLER_44_35 VGND VGND VPWR VPWR sky130_fd_sc_hd__fill_1
XFILLER_44_24 VGND VGND VPWR VPWR sky130_fd_sc_hd__decap_3
XFILLER_44_68 VGND VGND VPWR VPWR sky130_fd_sc_hd__decap_3
XFILLER_12_225 VGND VGND VPWR VPWR sky130_fd_sc_hd__decap_3
XFILLER_12_247 VGND VGND VPWR VPWR sky130_fd_sc_hd__decap_3
XFILLER_60_12 VGND VGND VPWR VPWR sky130_fd_sc_hd__decap_3
XTAP_TAPCELL_ROW_22_264 VGND VPWR sky130_fd_sc_hd__tapvpwrvgnd_1
XFILLER_8_229 VGND VGND VPWR VPWR sky130_fd_sc_hd__decap_3
XFILLER_60_78 VGND VGND VPWR VPWR sky130_fd_sc_hd__decap_3
XFILLER_5_18 VGND VGND VPWR VPWR sky130_fd_sc_hd__decap_3
XFILLER_47_122 VGND VGND VPWR VPWR sky130_fd_sc_hd__fill_1
XFILLER_47_111 VGND VGND VPWR VPWR sky130_fd_sc_hd__fill_1
XFILLER_47_100 VGND VGND VPWR VPWR sky130_fd_sc_hd__fill_1
XFILLER_47_188 VGND VGND VPWR VPWR sky130_fd_sc_hd__decap_3
XFILLER_50_309 VGND VGND VPWR VPWR sky130_fd_sc_hd__decap_3
X_1800_ _2732_/A _1960_/A _1799_/X VGND VGND VPWR VPWR _1803_/A sky130_fd_sc_hd__o21a_1
X_1731_ _1870_/A _1870_/B VGND VGND VPWR VPWR _1871_/A sky130_fd_sc_hd__or2_1
X_1662_ _1801_/A _1659_/Y _1661_/Y _1405_/A VGND VGND VPWR VPWR _1805_/S sky130_fd_sc_hd__a22o_1
XFILLER_7_251 VGND VGND VPWR VPWR sky130_fd_sc_hd__decap_3
X_1593_ _1579_/A _1575_/B _1579_/B _1592_/X VGND VGND VPWR VPWR _1776_/A sky130_fd_sc_hd__a31o_1
X_2214_ _2770_/Q _2217_/B _1681_/B _2217_/A VGND VGND VPWR VPWR _2214_/X sky130_fd_sc_hd__a22o_1
XFILLER_38_100 VGND VGND VPWR VPWR sky130_fd_sc_hd__decap_3
X_2145_ _2145_/A _2145_/B VGND VGND VPWR VPWR _2182_/A sky130_fd_sc_hd__xor2_2
XFILLER_38_188 VGND VGND VPWR VPWR sky130_fd_sc_hd__decap_3
X_2076_ _2080_/B _2080_/A VGND VGND VPWR VPWR _2079_/A sky130_fd_sc_hd__and2b_1
XTAP_TAPCELL_ROW_36_345 VGND VPWR sky130_fd_sc_hd__tapvpwrvgnd_1
XFILLER_53_169 VGND VGND VPWR VPWR sky130_fd_sc_hd__decap_3
X_1929_ _2000_/A _1929_/B VGND VGND VPWR VPWR _1931_/B sky130_fd_sc_hd__xnor2_1
XFILLER_30_15 VGND VGND VPWR VPWR sky130_fd_sc_hd__decap_3
XFILLER_39_24 VGND VGND VPWR VPWR sky130_fd_sc_hd__decap_3
XFILLER_39_79 VGND VGND VPWR VPWR sky130_fd_sc_hd__decap_3
XFILLER_29_100 VGND VGND VPWR VPWR sky130_fd_sc_hd__decap_3
XFILLER_29_122 VGND VGND VPWR VPWR sky130_fd_sc_hd__decap_3
XFILLER_55_12 VGND VGND VPWR VPWR sky130_fd_sc_hd__decap_3
XFILLER_29_155 VGND VGND VPWR VPWR sky130_fd_sc_hd__decap_3
XFILLER_55_67 VGND VGND VPWR VPWR sky130_fd_sc_hd__decap_3
XFILLER_55_45 VGND VGND VPWR VPWR sky130_fd_sc_hd__decap_3
XFILLER_44_136 VGND VGND VPWR VPWR sky130_fd_sc_hd__decap_3
XFILLER_44_114 VGND VGND VPWR VPWR sky130_fd_sc_hd__decap_3
XFILLER_32_309 VGND VGND VPWR VPWR sky130_fd_sc_hd__decap_3
XFILLER_52_180 VGND VGND VPWR VPWR sky130_fd_sc_hd__decap_3
XFILLER_4_221 VGND VGND VPWR VPWR sky130_fd_sc_hd__decap_3
XFILLER_4_298 VGND VGND VPWR VPWR sky130_fd_sc_hd__decap_3
XFILLER_20_92 VGND VGND VPWR VPWR sky130_fd_sc_hd__decap_3
XTAP_TAPCELL_ROW_58_481 VGND VPWR sky130_fd_sc_hd__tapvpwrvgnd_1
XFILLER_35_125 VGND VGND VPWR VPWR sky130_fd_sc_hd__decap_3
XFILLER_50_106 VGND VGND VPWR VPWR sky130_fd_sc_hd__decap_3
XFILLER_35_169 VGND VGND VPWR VPWR sky130_fd_sc_hd__decap_3
XTAP_TAPCELL_ROW_33_326 VGND VPWR sky130_fd_sc_hd__tapvpwrvgnd_1
XFILLER_43_191 VGND VGND VPWR VPWR sky130_fd_sc_hd__decap_3
XFILLER_43_180 VGND VGND VPWR VPWR sky130_fd_sc_hd__decap_3
X_2763_ clkload0/A _2763_/D fanout47/X VGND VGND VPWR VPWR _2763_/Q sky130_fd_sc_hd__dfrtp_1
X_1714_ _1714_/A _1714_/B VGND VGND VPWR VPWR _1854_/B sky130_fd_sc_hd__nor2_1
X_2694_ _2694_/A _2694_/B _2694_/C VGND VGND VPWR VPWR _2694_/Y sky130_fd_sc_hd__nand3_1
XFILLER_6_61 VGND VGND VPWR VPWR sky130_fd_sc_hd__decap_3
X_1645_ _1645_/A _1645_/B VGND VGND VPWR VPWR _1647_/B sky130_fd_sc_hd__xnor2_2
XFILLER_6_83 VGND VGND VPWR VPWR sky130_fd_sc_hd__fill_1
X_1576_ _1425_/B _1586_/B _1878_/A VGND VGND VPWR VPWR _1581_/S sky130_fd_sc_hd__a21oi_1
XFILLER_58_228 VGND VGND VPWR VPWR sky130_fd_sc_hd__decap_3
XFILLER_26_103 VGND VGND VPWR VPWR sky130_fd_sc_hd__decap_3
X_2128_ _2129_/A _2129_/B VGND VGND VPWR VPWR _2128_/X sky130_fd_sc_hd__and2b_1
XFILLER_26_136 VGND VGND VPWR VPWR sky130_fd_sc_hd__decap_3
X_2059_ _2059_/A _2127_/A _2191_/B VGND VGND VPWR VPWR _2059_/Y sky130_fd_sc_hd__nand3_1
XFILLER_25_15 VGND VGND VPWR VPWR sky130_fd_sc_hd__decap_3
XFILLER_14_309 VGND VGND VPWR VPWR sky130_fd_sc_hd__decap_3
XFILLER_41_128 VGND VGND VPWR VPWR sky130_fd_sc_hd__decap_3
XFILLER_22_320 VGND VGND VPWR VPWR sky130_fd_sc_hd__decap_3
XFILLER_41_47 VGND VGND VPWR VPWR sky130_fd_sc_hd__decap_3
XFILLER_41_69 VGND VGND VPWR VPWR sky130_fd_sc_hd__decap_3
XFILLER_49_228 VGND VGND VPWR VPWR sky130_fd_sc_hd__decap_3
XFILLER_49_206 VGND VGND VPWR VPWR sky130_fd_sc_hd__decap_3
XFILLER_1_279 VGND VGND VPWR VPWR sky130_fd_sc_hd__fill_1
XFILLER_57_261 VGND VGND VPWR VPWR sky130_fd_sc_hd__decap_3
XFILLER_17_147 VGND VGND VPWR VPWR sky130_fd_sc_hd__decap_3
XTAP_TAPCELL_ROW_55_462 VGND VPWR sky130_fd_sc_hd__tapvpwrvgnd_1
XFILLER_32_117 VGND VGND VPWR VPWR sky130_fd_sc_hd__decap_3
XFILLER_32_139 VGND VGND VPWR VPWR sky130_fd_sc_hd__fill_1
XFILLER_25_180 VGND VGND VPWR VPWR sky130_fd_sc_hd__decap_3
XFILLER_9_313 VGND VGND VPWR VPWR sky130_fd_sc_hd__decap_3
XFILLER_9_357 VGND VGND VPWR VPWR sky130_fd_sc_hd__decap_3
XFILLER_40_172 VGND VGND VPWR VPWR sky130_fd_sc_hd__decap_3
X_1430_ _1628_/A _1628_/B VGND VGND VPWR VPWR _1434_/C sky130_fd_sc_hd__nor2_1
XFILLER_49_6 VGND VGND VPWR VPWR sky130_fd_sc_hd__decap_3
XFILLER_48_250 VGND VGND VPWR VPWR sky130_fd_sc_hd__fill_2
XFILLER_16_180 VGND VGND VPWR VPWR sky130_fd_sc_hd__decap_3
XFILLER_31_183 VGND VGND VPWR VPWR sky130_fd_sc_hd__decap_3
X_2746_ _2767_/Q _2768_/Q _2746_/C VGND VGND VPWR VPWR _2748_/B sky130_fd_sc_hd__and3_1
X_2677_ _2672_/X _2676_/X _2696_/A VGND VGND VPWR VPWR _2678_/B sky130_fd_sc_hd__o21ai_2
X_1628_ _1628_/A _1628_/B VGND VGND VPWR VPWR _1629_/A sky130_fd_sc_hd__xnor2_1
X_1559_ _2045_/B _1972_/A _1743_/S VGND VGND VPWR VPWR _1561_/B sky130_fd_sc_hd__a21o_1
XFILLER_39_294 VGND VGND VPWR VPWR sky130_fd_sc_hd__decap_3
XFILLER_39_272 VGND VGND VPWR VPWR sky130_fd_sc_hd__decap_3
XFILLER_54_231 VGND VGND VPWR VPWR sky130_fd_sc_hd__decap_3
XFILLER_36_58 VGND VGND VPWR VPWR sky130_fd_sc_hd__decap_3
XFILLER_14_128 VGND VGND VPWR VPWR sky130_fd_sc_hd__decap_3
XFILLER_54_297 VGND VGND VPWR VPWR sky130_fd_sc_hd__decap_3
XFILLER_54_264 VGND VGND VPWR VPWR sky130_fd_sc_hd__decap_3
XTAP_TAPCELL_ROW_52_443 VGND VPWR sky130_fd_sc_hd__tapvpwrvgnd_1
XFILLER_52_24 VGND VGND VPWR VPWR sky130_fd_sc_hd__decap_3
XFILLER_52_79 VGND VGND VPWR VPWR sky130_fd_sc_hd__decap_3
XFILLER_52_68 VGND VGND VPWR VPWR sky130_fd_sc_hd__decap_3
XTAP_TAPCELL_ROW_9_187 VGND VPWR sky130_fd_sc_hd__tapvpwrvgnd_1
XFILLER_45_253 VGND VGND VPWR VPWR sky130_fd_sc_hd__decap_3
XFILLER_60_212 VGND VGND VPWR VPWR sky130_fd_sc_hd__decap_3
XFILLER_60_256 VGND VGND VPWR VPWR sky130_fd_sc_hd__decap_3
XFILLER_60_234 VGND VGND VPWR VPWR sky130_fd_sc_hd__decap_3
XFILLER_13_172 VGND VGND VPWR VPWR sky130_fd_sc_hd__decap_3
XFILLER_9_121 VGND VGND VPWR VPWR sky130_fd_sc_hd__decap_3
X_2600_ _2593_/A _2603_/A _2592_/Y _2524_/X VGND VGND VPWR VPWR _2601_/C sky130_fd_sc_hd__o211a_1
X_2531_ _2537_/A _2543_/A VGND VGND VPWR VPWR _2534_/A sky130_fd_sc_hd__and2_1
XFILLER_5_360 VGND VGND VPWR VPWR sky130_fd_sc_hd__fill_1
X_2462_ _2512_/A _2653_/C VGND VGND VPWR VPWR _2662_/C sky130_fd_sc_hd__or2_1
XFILLER_47_3 VGND VGND VPWR VPWR sky130_fd_sc_hd__decap_3
X_1413_ _2768_/Q _1438_/B VGND VGND VPWR VPWR _1414_/B sky130_fd_sc_hd__nand2_1
X_2393_ _2407_/A _2490_/A VGND VGND VPWR VPWR _2427_/B sky130_fd_sc_hd__nand2_1
XFILLER_3_95 VGND VGND VPWR VPWR sky130_fd_sc_hd__decap_3
XFILLER_28_209 VGND VGND VPWR VPWR sky130_fd_sc_hd__decap_3
XFILLER_51_267 VGND VGND VPWR VPWR sky130_fd_sc_hd__decap_3
X_2729_ _2775_/Q _2729_/B _2752_/B VGND VGND VPWR VPWR _2759_/B sky130_fd_sc_hd__and3_1
XFILLER_3_308 VGND VGND VPWR VPWR sky130_fd_sc_hd__fill_2
XFILLER_3_319 VGND VGND VPWR VPWR sky130_fd_sc_hd__decap_3
XFILLER_0_9 VGND VGND VPWR VPWR sky130_fd_sc_hd__decap_3
XTAP_TAPCELL_ROW_6_168 VGND VPWR sky130_fd_sc_hd__tapvpwrvgnd_1
XFILLER_59_323 VGND VGND VPWR VPWR sky130_fd_sc_hd__decap_3
XFILLER_47_24 VGND VGND VPWR VPWR sky130_fd_sc_hd__decap_3
XPHY_EDGE_ROW_29_Right_29 VGND VGND VPWR VPWR sky130_fd_sc_hd__decap_3
XFILLER_47_79 VGND VGND VPWR VPWR sky130_fd_sc_hd__decap_3
XFILLER_47_57 VGND VGND VPWR VPWR sky130_fd_sc_hd__fill_1
XFILLER_42_267 VGND VGND VPWR VPWR sky130_fd_sc_hd__fill_1
XFILLER_8_29 VGND VGND VPWR VPWR sky130_fd_sc_hd__decap_3
XFILLER_8_18 VGND VGND VPWR VPWR sky130_fd_sc_hd__decap_3
XPHY_EDGE_ROW_38_Right_38 VGND VGND VPWR VPWR sky130_fd_sc_hd__decap_3
XFILLER_6_135 VGND VGND VPWR VPWR sky130_fd_sc_hd__decap_3
XFILLER_6_102 VGND VGND VPWR VPWR sky130_fd_sc_hd__decap_3
XFILLER_33_9 VGND VGND VPWR VPWR sky130_fd_sc_hd__decap_3
XPHY_EDGE_ROW_47_Right_47 VGND VGND VPWR VPWR sky130_fd_sc_hd__decap_3
XFILLER_33_234 VGND VGND VPWR VPWR sky130_fd_sc_hd__fill_2
X_1962_ _1962_/A _1962_/B VGND VGND VPWR VPWR _1963_/B sky130_fd_sc_hd__xor2_1
XPHY_EDGE_ROW_56_Right_56 VGND VGND VPWR VPWR sky130_fd_sc_hd__decap_3
X_1893_ _1965_/A _1965_/B _1884_/Y VGND VGND VPWR VPWR _1896_/A sky130_fd_sc_hd__a21bo_1
X_2514_ _2514_/A _2514_/B VGND VGND VPWR VPWR _2532_/A sky130_fd_sc_hd__xnor2_2
X_2445_ _2754_/A _2445_/B _2675_/S VGND VGND VPWR VPWR _2445_/X sky130_fd_sc_hd__and3_1
X_2376_ _2420_/A _2420_/B _1874_/A VGND VGND VPWR VPWR _2506_/B sky130_fd_sc_hd__o21a_2
XFILLER_56_304 VGND VGND VPWR VPWR sky130_fd_sc_hd__decap_3
XTAP_TAPCELL_ROW_3_149 VGND VPWR sky130_fd_sc_hd__tapvpwrvgnd_1
XFILLER_56_315 VGND VGND VPWR VPWR sky130_fd_sc_hd__decap_3
XFILLER_56_348 VGND VGND VPWR VPWR sky130_fd_sc_hd__decap_3
XFILLER_24_245 VGND VGND VPWR VPWR sky130_fd_sc_hd__decap_3
XFILLER_24_223 VGND VGND VPWR VPWR sky130_fd_sc_hd__decap_3
XFILLER_33_15 VGND VGND VPWR VPWR sky130_fd_sc_hd__decap_3
XFILLER_24_278 VGND VGND VPWR VPWR sky130_fd_sc_hd__decap_3
XFILLER_24_289 VGND VGND VPWR VPWR sky130_fd_sc_hd__decap_3
XFILLER_3_116 VGND VGND VPWR VPWR sky130_fd_sc_hd__decap_3
XFILLER_58_12 VGND VGND VPWR VPWR sky130_fd_sc_hd__decap_3
XFILLER_59_120 VGND VGND VPWR VPWR sky130_fd_sc_hd__decap_3
XFILLER_58_56 VGND VGND VPWR VPWR sky130_fd_sc_hd__decap_3
XFILLER_59_153 VGND VGND VPWR VPWR sky130_fd_sc_hd__fill_1
XFILLER_59_186 VGND VGND VPWR VPWR sky130_fd_sc_hd__fill_2
XFILLER_47_337 VGND VGND VPWR VPWR sky130_fd_sc_hd__decap_3
XFILLER_47_326 VGND VGND VPWR VPWR sky130_fd_sc_hd__decap_3
XFILLER_15_234 VGND VGND VPWR VPWR sky130_fd_sc_hd__decap_3
XFILLER_30_259 VGND VGND VPWR VPWR sky130_fd_sc_hd__decap_3
X_2230_ _2230_/A _2230_/B VGND VGND VPWR VPWR _2232_/B sky130_fd_sc_hd__xnor2_1
XFILLER_31_6 VGND VGND VPWR VPWR sky130_fd_sc_hd__decap_3
XFILLER_2_171 VGND VGND VPWR VPWR sky130_fd_sc_hd__decap_3
XFILLER_38_304 VGND VGND VPWR VPWR sky130_fd_sc_hd__decap_3
X_2161_ _2162_/A _2162_/B VGND VGND VPWR VPWR _2161_/X sky130_fd_sc_hd__and2b_1
XFILLER_38_315 VGND VGND VPWR VPWR sky130_fd_sc_hd__decap_3
X_2092_ _2149_/B _2149_/A _2089_/Y VGND VGND VPWR VPWR _2094_/B sky130_fd_sc_hd__o21a_1
XFILLER_0_41 VGND VGND VPWR VPWR sky130_fd_sc_hd__decap_3
XFILLER_53_329 VGND VGND VPWR VPWR sky130_fd_sc_hd__decap_3
XFILLER_0_85 VGND VGND VPWR VPWR sky130_fd_sc_hd__fill_1
X_1945_ _2016_/A _2016_/B _2374_/B VGND VGND VPWR VPWR _1945_/Y sky130_fd_sc_hd__nor3_1
XFILLER_9_50 VGND VGND VPWR VPWR sky130_fd_sc_hd__decap_3
XFILLER_21_259 VGND VGND VPWR VPWR sky130_fd_sc_hd__decap_3
X_1876_ _1878_/A _1886_/A _2283_/B VGND VGND VPWR VPWR _1876_/Y sky130_fd_sc_hd__nor3_1
XFILLER_0_108 VGND VGND VPWR VPWR sky130_fd_sc_hd__decap_3
XFILLER_0_119 VGND VGND VPWR VPWR sky130_fd_sc_hd__decap_3
X_2428_ _2455_/C _2428_/B VGND VGND VPWR VPWR _2430_/B sky130_fd_sc_hd__or2_1
X_2359_ _2485_/A _2358_/Y _2354_/X VGND VGND VPWR VPWR _2484_/A sky130_fd_sc_hd__o21ai_1
XFILLER_56_101 VGND VGND VPWR VPWR sky130_fd_sc_hd__decap_3
XFILLER_29_337 VGND VGND VPWR VPWR sky130_fd_sc_hd__fill_1
XFILLER_56_134 VGND VGND VPWR VPWR sky130_fd_sc_hd__decap_3
XTAP_TAPCELL_ROW_39_365 VGND VPWR sky130_fd_sc_hd__tapvpwrvgnd_1
XFILLER_44_329 VGND VGND VPWR VPWR sky130_fd_sc_hd__decap_3
XFILLER_52_351 VGND VGND VPWR VPWR sky130_fd_sc_hd__decap_3
XFILLER_44_47 VGND VGND VPWR VPWR sky130_fd_sc_hd__decap_3
XFILLER_12_237 VGND VGND VPWR VPWR sky130_fd_sc_hd__decap_3
XFILLER_12_259 VGND VGND VPWR VPWR sky130_fd_sc_hd__fill_2
XTAP_TAPCELL_ROW_22_265 VGND VPWR sky130_fd_sc_hd__tapvpwrvgnd_1
XFILLER_60_35 VGND VGND VPWR VPWR sky130_fd_sc_hd__decap_3
XFILLER_60_24 VGND VGND VPWR VPWR sky130_fd_sc_hd__decap_3
XFILLER_60_57 VGND VGND VPWR VPWR sky130_fd_sc_hd__decap_3
XFILLER_20_270 VGND VGND VPWR VPWR sky130_fd_sc_hd__decap_3
XFILLER_47_167 VGND VGND VPWR VPWR sky130_fd_sc_hd__fill_1
XFILLER_43_351 VGND VGND VPWR VPWR sky130_fd_sc_hd__decap_3
XTAP_TAPCELL_ROW_13_210 VGND VPWR sky130_fd_sc_hd__tapvpwrvgnd_1
XFILLER_34_91 VGND VGND VPWR VPWR sky130_fd_sc_hd__decap_3
X_1730_ _1868_/A _1729_/Y _1729_/A VGND VGND VPWR VPWR _1870_/B sky130_fd_sc_hd__o21a_1
X_1661_ _2249_/B _1809_/A VGND VGND VPWR VPWR _1661_/Y sky130_fd_sc_hd__nor2_1
XFILLER_7_263 VGND VGND VPWR VPWR sky130_fd_sc_hd__decap_3
X_1592_ _1590_/A _1590_/B _1612_/A VGND VGND VPWR VPWR _1592_/X sky130_fd_sc_hd__o21ba_1
X_2213_ _2213_/A _2259_/A VGND VGND VPWR VPWR _2233_/B sky130_fd_sc_hd__nand2_1
XFILLER_38_112 VGND VGND VPWR VPWR sky130_fd_sc_hd__decap_3
X_2144_ _2144_/A _2144_/B VGND VGND VPWR VPWR _2195_/A sky130_fd_sc_hd__xor2_1
XFILLER_53_104 VGND VGND VPWR VPWR sky130_fd_sc_hd__decap_3
XFILLER_26_318 VGND VGND VPWR VPWR sky130_fd_sc_hd__decap_3
XFILLER_26_307 VGND VGND VPWR VPWR sky130_fd_sc_hd__fill_1
X_2075_ _2077_/B _2075_/B VGND VGND VPWR VPWR _2080_/B sky130_fd_sc_hd__or2_1
XTAP_TAPCELL_ROW_36_346 VGND VPWR sky130_fd_sc_hd__tapvpwrvgnd_1
XFILLER_53_159 VGND VGND VPWR VPWR sky130_fd_sc_hd__decap_3
XPHY_EDGE_ROW_46_Left_107 VGND VGND VPWR VPWR sky130_fd_sc_hd__decap_3
X_1928_ _1910_/A _1910_/B _1908_/X VGND VGND VPWR VPWR _1931_/A sky130_fd_sc_hd__a21o_1
X_1859_ _1859_/A _1859_/B VGND VGND VPWR VPWR _1935_/B sky130_fd_sc_hd__xnor2_1
XFILLER_30_27 VGND VGND VPWR VPWR sky130_fd_sc_hd__fill_1
XPHY_EDGE_ROW_55_Left_116 VGND VGND VPWR VPWR sky130_fd_sc_hd__decap_3
Xtt_um_connerdaehler_boop_60 VGND VGND VPWR VPWR tt_um_connerdaehler_boop_60/HI uio_out[3]
+ sky130_fd_sc_hd__conb_1
XFILLER_29_134 VGND VGND VPWR VPWR sky130_fd_sc_hd__decap_3
XFILLER_55_24 VGND VGND VPWR VPWR sky130_fd_sc_hd__decap_3
XFILLER_29_167 VGND VGND VPWR VPWR sky130_fd_sc_hd__fill_1
XFILLER_55_57 VGND VGND VPWR VPWR sky130_fd_sc_hd__decap_3
XFILLER_55_79 VGND VGND VPWR VPWR sky130_fd_sc_hd__fill_1
XFILLER_52_192 VGND VGND VPWR VPWR sky130_fd_sc_hd__decap_3
XFILLER_4_200 VGND VGND VPWR VPWR sky130_fd_sc_hd__decap_3
XFILLER_20_60 VGND VGND VPWR VPWR sky130_fd_sc_hd__decap_3
XFILLER_35_104 VGND VGND VPWR VPWR sky130_fd_sc_hd__decap_3
XFILLER_29_91 VGND VGND VPWR VPWR sky130_fd_sc_hd__decap_3
XFILLER_35_137 VGND VGND VPWR VPWR sky130_fd_sc_hd__fill_1
XFILLER_35_148 VGND VGND VPWR VPWR sky130_fd_sc_hd__decap_3
XTAP_TAPCELL_ROW_33_327 VGND VPWR sky130_fd_sc_hd__tapvpwrvgnd_1
XFILLER_50_118 VGND VGND VPWR VPWR sky130_fd_sc_hd__decap_3
X_2762_ _2777_/CLK _2762_/D fanout47/X VGND VGND VPWR VPWR _2762_/Q sky130_fd_sc_hd__dfrtp_4
X_1713_ _1713_/A _1713_/B _1713_/C VGND VGND VPWR VPWR _1714_/B sky130_fd_sc_hd__and3_1
X_2693_ _2719_/B _2699_/A _2691_/Y _2692_/X VGND VGND VPWR VPWR _2693_/X sky130_fd_sc_hd__a31o_1
X_1644_ _1644_/A _1644_/B VGND VGND VPWR VPWR _1647_/A sky130_fd_sc_hd__or2_1
X_1575_ _1579_/A _1575_/B VGND VGND VPWR VPWR _1752_/A sky130_fd_sc_hd__nor2_1
X_2127_ _2127_/A _2127_/B VGND VGND VPWR VPWR _2129_/B sky130_fd_sc_hd__xnor2_1
X_2058_ _2059_/A _2191_/B VGND VGND VPWR VPWR _2127_/B sky130_fd_sc_hd__nand2_1
XFILLER_26_159 VGND VGND VPWR VPWR sky130_fd_sc_hd__fill_2
XFILLER_25_27 VGND VGND VPWR VPWR sky130_fd_sc_hd__decap_3
XFILLER_34_170 VGND VGND VPWR VPWR sky130_fd_sc_hd__decap_3
XFILLER_41_15 VGND VGND VPWR VPWR sky130_fd_sc_hd__decap_3
XFILLER_9_6 VGND VGND VPWR VPWR sky130_fd_sc_hd__decap_3
XFILLER_57_240 VGND VGND VPWR VPWR sky130_fd_sc_hd__decap_3
XFILLER_57_284 VGND VGND VPWR VPWR sky130_fd_sc_hd__decap_3
XFILLER_57_273 VGND VGND VPWR VPWR sky130_fd_sc_hd__decap_3
XTAP_TAPCELL_ROW_55_463 VGND VPWR sky130_fd_sc_hd__tapvpwrvgnd_1
XTAP_TAPCELL_ROW_30_308 VGND VPWR sky130_fd_sc_hd__tapvpwrvgnd_1
XFILLER_40_184 VGND VGND VPWR VPWR sky130_fd_sc_hd__decap_3
XFILLER_31_81 VGND VGND VPWR VPWR sky130_fd_sc_hd__decap_3
XFILLER_0_291 VGND VGND VPWR VPWR sky130_fd_sc_hd__fill_1
XFILLER_48_284 VGND VGND VPWR VPWR sky130_fd_sc_hd__decap_3
XFILLER_23_129 VGND VGND VPWR VPWR sky130_fd_sc_hd__decap_3
XFILLER_31_195 VGND VGND VPWR VPWR sky130_fd_sc_hd__decap_3
XFILLER_31_162 VGND VGND VPWR VPWR sky130_fd_sc_hd__decap_3
X_2745_ _2767_/Q _2746_/C _2768_/Q VGND VGND VPWR VPWR _2747_/A sky130_fd_sc_hd__a21oi_1
X_2676_ _2719_/B _2616_/Y _2673_/X _2675_/X VGND VGND VPWR VPWR _2676_/X sky130_fd_sc_hd__a31o_1
X_1627_ _1627_/A _1627_/B VGND VGND VPWR VPWR _1655_/A sky130_fd_sc_hd__xor2_1
X_1558_ _1986_/B _1558_/B _1899_/A VGND VGND VPWR VPWR _1561_/A sky130_fd_sc_hd__or3_1
X_1489_ _2772_/Q _1489_/B VGND VGND VPWR VPWR _1491_/B sky130_fd_sc_hd__nor2_1
XFILLER_39_251 VGND VGND VPWR VPWR sky130_fd_sc_hd__decap_3
XFILLER_39_240 VGND VGND VPWR VPWR sky130_fd_sc_hd__decap_3
XFILLER_54_210 VGND VGND VPWR VPWR sky130_fd_sc_hd__decap_3
XFILLER_39_284 VGND VGND VPWR VPWR sky130_fd_sc_hd__decap_3
XFILLER_36_15 VGND VGND VPWR VPWR sky130_fd_sc_hd__decap_3
XFILLER_14_107 VGND VGND VPWR VPWR sky130_fd_sc_hd__decap_3
XFILLER_54_276 VGND VGND VPWR VPWR sky130_fd_sc_hd__decap_3
XTAP_TAPCELL_ROW_52_444 VGND VPWR sky130_fd_sc_hd__tapvpwrvgnd_1
XFILLER_10_302 VGND VGND VPWR VPWR sky130_fd_sc_hd__decap_3
XFILLER_10_346 VGND VGND VPWR VPWR sky130_fd_sc_hd__decap_3
XFILLER_22_195 VGND VGND VPWR VPWR sky130_fd_sc_hd__fill_1
XFILLER_6_328 VGND VGND VPWR VPWR sky130_fd_sc_hd__decap_3
XFILLER_7_3 VGND VGND VPWR VPWR sky130_fd_sc_hd__decap_3
XFILLER_45_221 VGND VGND VPWR VPWR sky130_fd_sc_hd__decap_3
XFILLER_45_276 VGND VGND VPWR VPWR sky130_fd_sc_hd__decap_3
XFILLER_60_246 VGND VGND VPWR VPWR sky130_fd_sc_hd__decap_3
XFILLER_60_268 VGND VGND VPWR VPWR sky130_fd_sc_hd__decap_3
XFILLER_13_162 VGND VGND VPWR VPWR sky130_fd_sc_hd__decap_3
XFILLER_9_188 VGND VGND VPWR VPWR sky130_fd_sc_hd__decap_3
XFILLER_42_91 VGND VGND VPWR VPWR sky130_fd_sc_hd__decap_3
X_2530_ _2530_/A _2530_/B VGND VGND VPWR VPWR _2543_/A sky130_fd_sc_hd__xnor2_2
X_2461_ _2712_/A _2650_/B _2721_/B VGND VGND VPWR VPWR _2653_/C sky130_fd_sc_hd__or3_1
X_1412_ _1886_/A VGND VGND VPWR VPWR _1951_/B sky130_fd_sc_hd__inv_2
X_2392_ _2392_/A _2392_/B VGND VGND VPWR VPWR _2490_/A sky130_fd_sc_hd__or2_2
XFILLER_3_30 VGND VGND VPWR VPWR sky130_fd_sc_hd__decap_3
XFILLER_36_243 VGND VGND VPWR VPWR sky130_fd_sc_hd__decap_3
XFILLER_36_221 VGND VGND VPWR VPWR sky130_fd_sc_hd__decap_3
XFILLER_36_265 VGND VGND VPWR VPWR sky130_fd_sc_hd__decap_3
XFILLER_51_279 VGND VGND VPWR VPWR sky130_fd_sc_hd__fill_1
X_2728_ _2729_/B _2752_/B VGND VGND VPWR VPWR _2757_/B sky130_fd_sc_hd__and2_1
X_2659_ _2464_/B _2656_/Y _2658_/Y _2648_/X _2655_/X VGND VGND VPWR VPWR _2672_/A
+ sky130_fd_sc_hd__a2111o_1
XFILLER_59_302 VGND VGND VPWR VPWR sky130_fd_sc_hd__decap_3
XFILLER_59_346 VGND VGND VPWR VPWR sky130_fd_sc_hd__decap_3
XFILLER_59_335 VGND VGND VPWR VPWR sky130_fd_sc_hd__fill_1
XTAP_TAPCELL_ROW_6_169 VGND VPWR sky130_fd_sc_hd__tapvpwrvgnd_1
XFILLER_47_36 VGND VGND VPWR VPWR sky130_fd_sc_hd__fill_2
XFILLER_27_232 VGND VGND VPWR VPWR sky130_fd_sc_hd__decap_3
XFILLER_27_265 VGND VGND VPWR VPWR sky130_fd_sc_hd__decap_3
XFILLER_42_246 VGND VGND VPWR VPWR sky130_fd_sc_hd__decap_3
XFILLER_42_224 VGND VGND VPWR VPWR sky130_fd_sc_hd__fill_2
XFILLER_42_213 VGND VGND VPWR VPWR sky130_fd_sc_hd__decap_3
XFILLER_27_287 VGND VGND VPWR VPWR sky130_fd_sc_hd__fill_2
XFILLER_10_110 VGND VGND VPWR VPWR sky130_fd_sc_hd__decap_3
XFILLER_12_61 VGND VGND VPWR VPWR sky130_fd_sc_hd__decap_3
XFILLER_6_147 VGND VGND VPWR VPWR sky130_fd_sc_hd__decap_3
XFILLER_12_83 VGND VGND VPWR VPWR sky130_fd_sc_hd__fill_1
XFILLER_12_94 VGND VGND VPWR VPWR sky130_fd_sc_hd__decap_3
XFILLER_2_331 VGND VGND VPWR VPWR sky130_fd_sc_hd__decap_3
XFILLER_18_232 VGND VGND VPWR VPWR sky130_fd_sc_hd__decap_3
XFILLER_18_298 VGND VGND VPWR VPWR sky130_fd_sc_hd__decap_3
XFILLER_33_279 VGND VGND VPWR VPWR sky130_fd_sc_hd__fill_1
XFILLER_33_246 VGND VGND VPWR VPWR sky130_fd_sc_hd__decap_3
X_1961_ _1962_/A _1962_/B VGND VGND VPWR VPWR _1961_/Y sky130_fd_sc_hd__nor2_1
X_1892_ _1892_/A _1892_/B VGND VGND VPWR VPWR _1965_/B sky130_fd_sc_hd__xnor2_1
X_2513_ _2522_/A _2503_/Y _2500_/Y VGND VGND VPWR VPWR _2514_/B sky130_fd_sc_hd__o21ai_1
X_2444_ _2444_/A _2444_/B VGND VGND VPWR VPWR _2675_/S sky130_fd_sc_hd__nor2_1
X_2375_ _2417_/A _2417_/B _1945_/Y VGND VGND VPWR VPWR _2420_/B sky130_fd_sc_hd__a21oi_2
XFILLER_56_327 VGND VGND VPWR VPWR sky130_fd_sc_hd__decap_3
XFILLER_3_139 VGND VGND VPWR VPWR sky130_fd_sc_hd__decap_3
XFILLER_59_110 VGND VGND VPWR VPWR sky130_fd_sc_hd__fill_2
XFILLER_58_35 VGND VGND VPWR VPWR sky130_fd_sc_hd__decap_3
XFILLER_58_24 VGND VGND VPWR VPWR sky130_fd_sc_hd__decap_3
XFILLER_59_132 VGND VGND VPWR VPWR sky130_fd_sc_hd__decap_3
XFILLER_58_68 VGND VGND VPWR VPWR sky130_fd_sc_hd__decap_3
XFILLER_59_176 VGND VGND VPWR VPWR sky130_fd_sc_hd__fill_2
XFILLER_47_305 VGND VGND VPWR VPWR sky130_fd_sc_hd__decap_3
XFILLER_47_349 VGND VGND VPWR VPWR sky130_fd_sc_hd__decap_3
XFILLER_15_213 VGND VGND VPWR VPWR sky130_fd_sc_hd__fill_2
XFILLER_15_268 VGND VGND VPWR VPWR sky130_fd_sc_hd__fill_1
XFILLER_15_246 VGND VGND VPWR VPWR sky130_fd_sc_hd__decap_3
XFILLER_30_227 VGND VGND VPWR VPWR sky130_fd_sc_hd__decap_3
XFILLER_23_60 VGND VGND VPWR VPWR sky130_fd_sc_hd__decap_3
XFILLER_23_93 VGND VGND VPWR VPWR sky130_fd_sc_hd__decap_3
X_2160_ _2160_/A _2160_/B VGND VGND VPWR VPWR _2162_/B sky130_fd_sc_hd__xor2_1
XFILLER_38_327 VGND VGND VPWR VPWR sky130_fd_sc_hd__fill_1
X_2091_ _2742_/A _2335_/B _2310_/B VGND VGND VPWR VPWR _2091_/X sky130_fd_sc_hd__a21o_1
XFILLER_0_53 VGND VGND VPWR VPWR sky130_fd_sc_hd__decap_3
XFILLER_53_308 VGND VGND VPWR VPWR sky130_fd_sc_hd__decap_3
XFILLER_0_64 VGND VGND VPWR VPWR sky130_fd_sc_hd__decap_3
XFILLER_21_205 VGND VGND VPWR VPWR sky130_fd_sc_hd__decap_3
X_1944_ _1944_/A _1944_/B VGND VGND VPWR VPWR _2374_/B sky130_fd_sc_hd__or2_2
XFILLER_21_238 VGND VGND VPWR VPWR sky130_fd_sc_hd__decap_3
XFILLER_14_290 VGND VGND VPWR VPWR sky130_fd_sc_hd__decap_3
XFILLER_9_84 VGND VGND VPWR VPWR sky130_fd_sc_hd__fill_1
X_1875_ _2762_/Q _1951_/B VGND VGND VPWR VPWR _2160_/A sky130_fd_sc_hd__nand2_1
X_2427_ _2427_/A _2427_/B _2432_/A VGND VGND VPWR VPWR _2428_/B sky130_fd_sc_hd__and3_1
X_2358_ _2485_/B VGND VGND VPWR VPWR _2358_/Y sky130_fd_sc_hd__inv_2
XFILLER_56_113 VGND VGND VPWR VPWR sky130_fd_sc_hd__decap_3
XFILLER_29_327 VGND VGND VPWR VPWR sky130_fd_sc_hd__decap_3
XFILLER_29_305 VGND VGND VPWR VPWR sky130_fd_sc_hd__decap_3
X_2289_ _2290_/A _2290_/B VGND VGND VPWR VPWR _2289_/Y sky130_fd_sc_hd__nand2_1
XTAP_TAPCELL_ROW_39_366 VGND VPWR sky130_fd_sc_hd__tapvpwrvgnd_1
XFILLER_56_168 VGND VGND VPWR VPWR sky130_fd_sc_hd__decap_3
XFILLER_44_319 VGND VGND VPWR VPWR sky130_fd_sc_hd__fill_2
XFILLER_44_15 VGND VGND VPWR VPWR sky130_fd_sc_hd__decap_3
XFILLER_52_330 VGND VGND VPWR VPWR sky130_fd_sc_hd__decap_3
XFILLER_44_59 VGND VGND VPWR VPWR sky130_fd_sc_hd__decap_3
XFILLER_8_209 VGND VGND VPWR VPWR sky130_fd_sc_hd__decap_3
XFILLER_60_69 VGND VGND VPWR VPWR sky130_fd_sc_hd__decap_3
XFILLER_60_47 VGND VGND VPWR VPWR sky130_fd_sc_hd__decap_3
XFILLER_20_282 VGND VGND VPWR VPWR sky130_fd_sc_hd__fill_1
XFILLER_47_113 VGND VGND VPWR VPWR sky130_fd_sc_hd__decap_3
XFILLER_47_146 VGND VGND VPWR VPWR sky130_fd_sc_hd__fill_2
XFILLER_55_190 VGND VGND VPWR VPWR sky130_fd_sc_hd__decap_3
XTAP_TAPCELL_ROW_13_211 VGND VPWR sky130_fd_sc_hd__tapvpwrvgnd_1
XFILLER_34_81 VGND VGND VPWR VPWR sky130_fd_sc_hd__decap_3
XFILLER_7_231 VGND VGND VPWR VPWR sky130_fd_sc_hd__decap_3
X_1660_ _2286_/A _1660_/B VGND VGND VPWR VPWR _1801_/B sky130_fd_sc_hd__or2_1
X_1591_ _1611_/A _1611_/B VGND VGND VPWR VPWR _1612_/A sky130_fd_sc_hd__nor2_1
XFILLER_7_286 VGND VGND VPWR VPWR sky130_fd_sc_hd__decap_3
XFILLER_50_91 VGND VGND VPWR VPWR sky130_fd_sc_hd__decap_3
X_2212_ _2213_/A _2212_/B _2212_/C VGND VGND VPWR VPWR _2259_/A sky130_fd_sc_hd__nand3_1
XFILLER_22_3 VGND VGND VPWR VPWR sky130_fd_sc_hd__fill_1
X_2143_ _2143_/A _2143_/B VGND VGND VPWR VPWR _2143_/Y sky130_fd_sc_hd__xnor2_1
XFILLER_38_135 VGND VGND VPWR VPWR sky130_fd_sc_hd__decap_3
XFILLER_38_124 VGND VGND VPWR VPWR sky130_fd_sc_hd__decap_3
XFILLER_38_179 VGND VGND VPWR VPWR sky130_fd_sc_hd__fill_1
XFILLER_38_157 VGND VGND VPWR VPWR sky130_fd_sc_hd__decap_3
X_2074_ _2077_/A _2013_/C _2013_/B VGND VGND VPWR VPWR _2075_/B sky130_fd_sc_hd__o21a_1
XFILLER_53_138 VGND VGND VPWR VPWR sky130_fd_sc_hd__decap_3
XFILLER_53_127 VGND VGND VPWR VPWR sky130_fd_sc_hd__decap_3
XTAP_TAPCELL_ROW_36_347 VGND VPWR sky130_fd_sc_hd__tapvpwrvgnd_1
XFILLER_14_29 VGND VGND VPWR VPWR sky130_fd_sc_hd__fill_1
X_1927_ _2000_/A _2003_/B _1925_/Y VGND VGND VPWR VPWR _1932_/A sky130_fd_sc_hd__a21bo_1
X_1858_ _1859_/B _1859_/A VGND VGND VPWR VPWR _1865_/B sky130_fd_sc_hd__and2b_1
X_1789_ _1791_/B _1791_/A VGND VGND VPWR VPWR _1789_/X sky130_fd_sc_hd__and2b_1
XFILLER_39_15 VGND VGND VPWR VPWR sky130_fd_sc_hd__decap_3
Xtt_um_connerdaehler_boop_50 VGND VGND VPWR VPWR tt_um_connerdaehler_boop_50/HI uio_oe[1]
+ sky130_fd_sc_hd__conb_1
Xtt_um_connerdaehler_boop_61 VGND VGND VPWR VPWR tt_um_connerdaehler_boop_61/HI uio_out[4]
+ sky130_fd_sc_hd__conb_1
XFILLER_29_113 VGND VGND VPWR VPWR sky130_fd_sc_hd__decap_3
XFILLER_29_179 VGND VGND VPWR VPWR sky130_fd_sc_hd__decap_3
XFILLER_17_308 VGND VGND VPWR VPWR sky130_fd_sc_hd__decap_3
XFILLER_55_36 VGND VGND VPWR VPWR sky130_fd_sc_hd__decap_3
XFILLER_52_171 VGND VGND VPWR VPWR sky130_fd_sc_hd__decap_3
XFILLER_40_322 VGND VGND VPWR VPWR sky130_fd_sc_hd__fill_2
XFILLER_4_212 VGND VGND VPWR VPWR sky130_fd_sc_hd__decap_3
XFILLER_4_256 VGND VGND VPWR VPWR sky130_fd_sc_hd__decap_3
XFILLER_35_116 VGND VGND VPWR VPWR sky130_fd_sc_hd__decap_3
XFILLER_45_91 VGND VGND VPWR VPWR sky130_fd_sc_hd__fill_2
XFILLER_43_160 VGND VGND VPWR VPWR sky130_fd_sc_hd__decap_3
XTAP_TAPCELL_ROW_33_328 VGND VPWR sky130_fd_sc_hd__tapvpwrvgnd_1
XFILLER_31_355 VGND VGND VPWR VPWR sky130_fd_sc_hd__decap_3
X_2761_ _2761_/A _2761_/B VGND VGND VPWR VPWR _2777_/D sky130_fd_sc_hd__xnor2_1
X_1712_ _1713_/A _1713_/B _1713_/C VGND VGND VPWR VPWR _1714_/A sky130_fd_sc_hd__a21oi_1
X_2692_ _1489_/B _2448_/B _2669_/B VGND VGND VPWR VPWR _2692_/X sky130_fd_sc_hd__o21a_1
X_1643_ _1644_/A _1643_/B _1643_/C VGND VGND VPWR VPWR _1644_/B sky130_fd_sc_hd__nor3_1
XFILLER_6_85 VGND VGND VPWR VPWR sky130_fd_sc_hd__decap_3
X_1574_ _1586_/A _1951_/B _1606_/A VGND VGND VPWR VPWR _1575_/B sky130_fd_sc_hd__a21o_1
XFILLER_58_219 VGND VGND VPWR VPWR sky130_fd_sc_hd__decap_3
XPHY_EDGE_ROW_16_Left_77 VGND VGND VPWR VPWR sky130_fd_sc_hd__decap_3
X_2126_ _2105_/B _2126_/B VGND VGND VPWR VPWR _2129_/A sky130_fd_sc_hd__and2b_1
X_2057_ _2057_/A _2057_/B VGND VGND VPWR VPWR _2191_/B sky130_fd_sc_hd__or2_1
XFILLER_19_190 VGND VGND VPWR VPWR sky130_fd_sc_hd__decap_3
XFILLER_41_119 VGND VGND VPWR VPWR sky130_fd_sc_hd__decap_3
XFILLER_41_108 VGND VGND VPWR VPWR sky130_fd_sc_hd__decap_3
XFILLER_25_39 VGND VGND VPWR VPWR sky130_fd_sc_hd__decap_3
XFILLER_34_193 VGND VGND VPWR VPWR sky130_fd_sc_hd__decap_3
XFILLER_49_219 VGND VGND VPWR VPWR sky130_fd_sc_hd__decap_3
XFILLER_57_252 VGND VGND VPWR VPWR sky130_fd_sc_hd__decap_3
XFILLER_57_296 VGND VGND VPWR VPWR sky130_fd_sc_hd__decap_3
XFILLER_17_138 VGND VGND VPWR VPWR sky130_fd_sc_hd__decap_3
XFILLER_13_300 VGND VGND VPWR VPWR sky130_fd_sc_hd__decap_3
XFILLER_32_108 VGND VGND VPWR VPWR sky130_fd_sc_hd__decap_3
XFILLER_13_333 VGND VGND VPWR VPWR sky130_fd_sc_hd__decap_3
XFILLER_25_193 VGND VGND VPWR VPWR sky130_fd_sc_hd__decap_3
XFILLER_13_355 VGND VGND VPWR VPWR sky130_fd_sc_hd__decap_3
XTAP_TAPCELL_ROW_30_309 VGND VPWR sky130_fd_sc_hd__tapvpwrvgnd_1
XFILLER_9_304 VGND VGND VPWR VPWR sky130_fd_sc_hd__decap_3
XFILLER_40_163 VGND VGND VPWR VPWR sky130_fd_sc_hd__decap_3
XFILLER_56_9 VGND VGND VPWR VPWR sky130_fd_sc_hd__decap_3
XFILLER_31_93 VGND VGND VPWR VPWR sky130_fd_sc_hd__decap_3
XFILLER_0_281 VGND VGND VPWR VPWR sky130_fd_sc_hd__fill_2
XFILLER_48_230 VGND VGND VPWR VPWR sky130_fd_sc_hd__decap_3
XFILLER_48_296 VGND VGND VPWR VPWR sky130_fd_sc_hd__decap_3
XFILLER_23_108 VGND VGND VPWR VPWR sky130_fd_sc_hd__decap_3
XFILLER_16_193 VGND VGND VPWR VPWR sky130_fd_sc_hd__decap_3
XFILLER_31_174 VGND VGND VPWR VPWR sky130_fd_sc_hd__decap_3
X_2744_ _2767_/Q _2746_/C VGND VGND VPWR VPWR _2767_/D sky130_fd_sc_hd__xor2_1
X_2675_ _2674_/A _2674_/Y _2675_/S VGND VGND VPWR VPWR _2675_/X sky130_fd_sc_hd__mux2_1
X_1626_ _1627_/A _1627_/B VGND VGND VPWR VPWR _1633_/A sky130_fd_sc_hd__or2_1
X_1557_ _1820_/B _1557_/B _1535_/B VGND VGND VPWR VPWR _1562_/S sky130_fd_sc_hd__or3b_1
X_1488_ _1641_/B _1488_/B VGND VGND VPWR VPWR _1642_/A sky130_fd_sc_hd__and2b_1
X_2109_ _2145_/A _2145_/B VGND VGND VPWR VPWR _2109_/X sky130_fd_sc_hd__and2_1
XFILLER_54_244 VGND VGND VPWR VPWR sky130_fd_sc_hd__decap_3
XFILLER_54_222 VGND VGND VPWR VPWR sky130_fd_sc_hd__decap_3
XFILLER_36_49 VGND VGND VPWR VPWR sky130_fd_sc_hd__decap_3
XFILLER_14_119 VGND VGND VPWR VPWR sky130_fd_sc_hd__decap_3
XFILLER_54_288 VGND VGND VPWR VPWR sky130_fd_sc_hd__decap_3
XFILLER_52_15 VGND VGND VPWR VPWR sky130_fd_sc_hd__decap_3
XTAP_TAPCELL_ROW_52_445 VGND VPWR sky130_fd_sc_hd__tapvpwrvgnd_1
XFILLER_52_48 VGND VGND VPWR VPWR sky130_fd_sc_hd__decap_3
XFILLER_22_141 VGND VGND VPWR VPWR sky130_fd_sc_hd__fill_2
XFILLER_10_336 VGND VGND VPWR VPWR sky130_fd_sc_hd__decap_3
XFILLER_10_358 VGND VGND VPWR VPWR sky130_fd_sc_hd__decap_3
XFILLER_6_307 VGND VGND VPWR VPWR sky130_fd_sc_hd__fill_1
XFILLER_6_318 VGND VGND VPWR VPWR sky130_fd_sc_hd__fill_1
XFILLER_45_200 VGND VGND VPWR VPWR sky130_fd_sc_hd__decap_3
XFILLER_45_244 VGND VGND VPWR VPWR sky130_fd_sc_hd__decap_3
XFILLER_60_203 VGND VGND VPWR VPWR sky130_fd_sc_hd__decap_3
XFILLER_60_225 VGND VGND VPWR VPWR sky130_fd_sc_hd__decap_3
XFILLER_9_167 VGND VGND VPWR VPWR sky130_fd_sc_hd__fill_1
XFILLER_5_340 VGND VGND VPWR VPWR sky130_fd_sc_hd__fill_2
X_2460_ _2460_/A _2460_/B VGND VGND VPWR VPWR _2721_/B sky130_fd_sc_hd__nand2_1
XFILLER_5_351 VGND VGND VPWR VPWR sky130_fd_sc_hd__decap_3
XFILLER_54_6 VGND VGND VPWR VPWR sky130_fd_sc_hd__decap_3
X_1411_ _1411_/A _1411_/B VGND VGND VPWR VPWR _1587_/A sky130_fd_sc_hd__xor2_2
X_2391_ _2367_/B _2367_/C _2367_/A VGND VGND VPWR VPWR _2392_/B sky130_fd_sc_hd__a21oi_1
XFILLER_3_42 VGND VGND VPWR VPWR sky130_fd_sc_hd__decap_3
XFILLER_3_86 VGND VGND VPWR VPWR sky130_fd_sc_hd__decap_3
XFILLER_36_211 VGND VGND VPWR VPWR sky130_fd_sc_hd__decap_3
XFILLER_36_277 VGND VGND VPWR VPWR sky130_fd_sc_hd__decap_3
XFILLER_51_236 VGND VGND VPWR VPWR sky130_fd_sc_hd__decap_3
XFILLER_36_288 VGND VGND VPWR VPWR sky130_fd_sc_hd__decap_3
XFILLER_51_247 VGND VGND VPWR VPWR sky130_fd_sc_hd__decap_3
X_2727_ _2772_/Q _2752_/B VGND VGND VPWR VPWR _2754_/B sky130_fd_sc_hd__nand2_1
X_2658_ _2468_/B _2657_/X _1489_/B VGND VGND VPWR VPWR _2658_/Y sky130_fd_sc_hd__a21oi_1
X_1609_ _1637_/A _1637_/B VGND VGND VPWR VPWR _1638_/A sky130_fd_sc_hd__nor2_1
X_2589_ _2636_/B _2637_/A VGND VGND VPWR VPWR _2602_/C sky130_fd_sc_hd__and2b_1
XFILLER_59_314 VGND VGND VPWR VPWR sky130_fd_sc_hd__decap_3
XFILLER_47_15 VGND VGND VPWR VPWR sky130_fd_sc_hd__decap_3
XFILLER_27_211 VGND VGND VPWR VPWR sky130_fd_sc_hd__decap_3
XPHY_EDGE_ROW_19_Left_80 VGND VGND VPWR VPWR sky130_fd_sc_hd__decap_3
XFILLER_42_236 VGND VGND VPWR VPWR sky130_fd_sc_hd__fill_1
XFILLER_50_280 VGND VGND VPWR VPWR sky130_fd_sc_hd__decap_3
XFILLER_2_354 VGND VGND VPWR VPWR sky130_fd_sc_hd__decap_3
XFILLER_19_9 VGND VGND VPWR VPWR sky130_fd_sc_hd__decap_3
XFILLER_18_200 VGND VGND VPWR VPWR sky130_fd_sc_hd__decap_3
XFILLER_37_92 VGND VGND VPWR VPWR sky130_fd_sc_hd__decap_3
XFILLER_37_70 VGND VGND VPWR VPWR sky130_fd_sc_hd__decap_3
XFILLER_18_266 VGND VGND VPWR VPWR sky130_fd_sc_hd__decap_3
XFILLER_18_244 VGND VGND VPWR VPWR sky130_fd_sc_hd__decap_3
XFILLER_33_225 VGND VGND VPWR VPWR sky130_fd_sc_hd__decap_3
XFILLER_18_288 VGND VGND VPWR VPWR sky130_fd_sc_hd__decap_3
X_1960_ _1960_/A _1960_/B VGND VGND VPWR VPWR _1962_/B sky130_fd_sc_hd__xnor2_1
X_1891_ _1892_/B _1892_/A VGND VGND VPWR VPWR _1891_/Y sky130_fd_sc_hd__nand2b_1
X_2512_ _2512_/A _2512_/B VGND VGND VPWR VPWR _2522_/B sky130_fd_sc_hd__xnor2_1
XTAP_TAPCELL_ROW_11_194 VGND VPWR sky130_fd_sc_hd__tapvpwrvgnd_1
XFILLER_52_3 VGND VGND VPWR VPWR sky130_fd_sc_hd__decap_3
XFILLER_5_181 VGND VGND VPWR VPWR sky130_fd_sc_hd__decap_3
X_2443_ input7/X _2566_/A VGND VGND VPWR VPWR _2444_/B sky130_fd_sc_hd__and2b_1
X_2374_ _2374_/A _2374_/B VGND VGND VPWR VPWR _2417_/B sky130_fd_sc_hd__xnor2_4
XFILLER_56_339 VGND VGND VPWR VPWR sky130_fd_sc_hd__decap_3
XFILLER_24_236 VGND VGND VPWR VPWR sky130_fd_sc_hd__decap_3
XFILLER_24_214 VGND VGND VPWR VPWR sky130_fd_sc_hd__decap_3
XFILLER_24_203 VGND VGND VPWR VPWR sky130_fd_sc_hd__decap_3
XFILLER_24_269 VGND VGND VPWR VPWR sky130_fd_sc_hd__decap_3
XFILLER_32_280 VGND VGND VPWR VPWR sky130_fd_sc_hd__decap_3
XFILLER_3_107 VGND VGND VPWR VPWR sky130_fd_sc_hd__decap_3
XFILLER_58_47 VGND VGND VPWR VPWR sky130_fd_sc_hd__decap_3
XFILLER_47_317 VGND VGND VPWR VPWR sky130_fd_sc_hd__decap_3
XTAP_TAPCELL_ROW_2_140 VGND VPWR sky130_fd_sc_hd__tapvpwrvgnd_1
XPHY_EDGE_ROW_4_Left_65 VGND VGND VPWR VPWR sky130_fd_sc_hd__decap_3
XFILLER_23_72 VGND VGND VPWR VPWR sky130_fd_sc_hd__decap_3
XFILLER_2_162 VGND VGND VPWR VPWR sky130_fd_sc_hd__decap_3
XFILLER_2_195 VGND VGND VPWR VPWR sky130_fd_sc_hd__fill_1
X_2090_ _2742_/A _2335_/B _2310_/B VGND VGND VPWR VPWR _2149_/A sky130_fd_sc_hd__a21oi_1
XFILLER_48_91 VGND VGND VPWR VPWR sky130_fd_sc_hd__fill_1
XFILLER_0_21 VGND VGND VPWR VPWR sky130_fd_sc_hd__decap_3
XFILLER_0_32 VGND VGND VPWR VPWR sky130_fd_sc_hd__decap_3
XFILLER_0_76 VGND VGND VPWR VPWR sky130_fd_sc_hd__decap_3
XFILLER_0_98 VGND VGND VPWR VPWR sky130_fd_sc_hd__decap_3
XFILLER_21_217 VGND VGND VPWR VPWR sky130_fd_sc_hd__fill_1
X_1943_ _1943_/A _1943_/B _1943_/C VGND VGND VPWR VPWR _1944_/B sky130_fd_sc_hd__nor3_1
XFILLER_9_63 VGND VGND VPWR VPWR sky130_fd_sc_hd__decap_3
X_1874_ _1874_/A _1874_/B VGND VGND VPWR VPWR _2420_/A sky130_fd_sc_hd__nand2_2
X_2426_ _2426_/A _2426_/B VGND VGND VPWR VPWR _2662_/B sky130_fd_sc_hd__or2_1
X_2357_ _2350_/A _2350_/B _2356_/X _2346_/A VGND VGND VPWR VPWR _2485_/B sky130_fd_sc_hd__o211a_1
X_2288_ _2288_/A _2288_/B VGND VGND VPWR VPWR _2290_/B sky130_fd_sc_hd__xor2_1
XFILLER_56_147 VGND VGND VPWR VPWR sky130_fd_sc_hd__decap_3
XFILLER_56_125 VGND VGND VPWR VPWR sky130_fd_sc_hd__decap_3
XTAP_TAPCELL_ROW_39_367 VGND VPWR sky130_fd_sc_hd__tapvpwrvgnd_1
XFILLER_52_342 VGND VGND VPWR VPWR sky130_fd_sc_hd__decap_3
XFILLER_44_27 VGND VGND VPWR VPWR sky130_fd_sc_hd__fill_1
XFILLER_12_228 VGND VGND VPWR VPWR sky130_fd_sc_hd__decap_3
XFILLER_60_15 VGND VGND VPWR VPWR sky130_fd_sc_hd__decap_3
XFILLER_20_261 VGND VGND VPWR VPWR sky130_fd_sc_hd__decap_3
XFILLER_47_169 VGND VGND VPWR VPWR sky130_fd_sc_hd__fill_2
XFILLER_18_61 VGND VGND VPWR VPWR sky130_fd_sc_hd__decap_3
XFILLER_43_331 VGND VGND VPWR VPWR sky130_fd_sc_hd__decap_3
XFILLER_34_60 VGND VGND VPWR VPWR sky130_fd_sc_hd__fill_2
XFILLER_11_261 VGND VGND VPWR VPWR sky130_fd_sc_hd__decap_3
XFILLER_7_254 VGND VGND VPWR VPWR sky130_fd_sc_hd__decap_3
X_1590_ _1590_/A _1590_/B VGND VGND VPWR VPWR _1611_/B sky130_fd_sc_hd__xnor2_1
X_2211_ _2211_/A _2211_/B VGND VGND VPWR VPWR _2212_/C sky130_fd_sc_hd__xor2_1
XFILLER_59_90 VGND VGND VPWR VPWR sky130_fd_sc_hd__decap_3
XFILLER_38_103 VGND VGND VPWR VPWR sky130_fd_sc_hd__decap_3
X_2142_ _2143_/B _2143_/A VGND VGND VPWR VPWR _2379_/A sky130_fd_sc_hd__and2b_1
XFILLER_15_3 VGND VGND VPWR VPWR sky130_fd_sc_hd__decap_3
X_2073_ _2073_/A _2073_/B VGND VGND VPWR VPWR _2080_/A sky130_fd_sc_hd__nand2_1
XFILLER_26_309 VGND VGND VPWR VPWR sky130_fd_sc_hd__decap_3
XTAP_TAPCELL_ROW_36_348 VGND VPWR sky130_fd_sc_hd__tapvpwrvgnd_1
XFILLER_46_180 VGND VGND VPWR VPWR sky130_fd_sc_hd__fill_2
XFILLER_34_342 VGND VGND VPWR VPWR sky130_fd_sc_hd__decap_3
XTAP_TAPCELL_ROW_44_392 VGND VPWR sky130_fd_sc_hd__tapvpwrvgnd_1
X_1926_ _1926_/A _1926_/B VGND VGND VPWR VPWR _2003_/B sky130_fd_sc_hd__xor2_1
X_1857_ _1865_/A _1857_/B VGND VGND VPWR VPWR _1859_/B sky130_fd_sc_hd__or2_1
XFILLER_30_18 VGND VGND VPWR VPWR sky130_fd_sc_hd__decap_3
X_1788_ _1785_/X _1788_/B VGND VGND VPWR VPWR _1791_/B sky130_fd_sc_hd__nand2b_1
Xtt_um_connerdaehler_boop_51 VGND VGND VPWR VPWR tt_um_connerdaehler_boop_51/HI uio_oe[2]
+ sky130_fd_sc_hd__conb_1
Xtt_um_connerdaehler_boop_62 VGND VGND VPWR VPWR tt_um_connerdaehler_boop_62/HI uio_out[5]
+ sky130_fd_sc_hd__conb_1
XFILLER_39_27 VGND VGND VPWR VPWR sky130_fd_sc_hd__decap_3
X_2409_ _2431_/A _2435_/A _2431_/C VGND VGND VPWR VPWR _2432_/A sky130_fd_sc_hd__o21ai_1
XFILLER_29_103 VGND VGND VPWR VPWR sky130_fd_sc_hd__decap_3
XFILLER_29_125 VGND VGND VPWR VPWR sky130_fd_sc_hd__decap_3
XFILLER_55_15 VGND VGND VPWR VPWR sky130_fd_sc_hd__decap_3
XFILLER_29_169 VGND VGND VPWR VPWR sky130_fd_sc_hd__decap_3
XFILLER_29_158 VGND VGND VPWR VPWR sky130_fd_sc_hd__decap_3
XFILLER_55_48 VGND VGND VPWR VPWR sky130_fd_sc_hd__fill_1
XFILLER_44_117 VGND VGND VPWR VPWR sky130_fd_sc_hd__fill_1
XFILLER_44_139 VGND VGND VPWR VPWR sky130_fd_sc_hd__fill_1
XFILLER_37_191 VGND VGND VPWR VPWR sky130_fd_sc_hd__decap_3
XFILLER_52_150 VGND VGND VPWR VPWR sky130_fd_sc_hd__decap_3
XFILLER_52_183 VGND VGND VPWR VPWR sky130_fd_sc_hd__decap_3
XFILLER_40_312 VGND VGND VPWR VPWR sky130_fd_sc_hd__fill_1
XFILLER_4_224 VGND VGND VPWR VPWR sky130_fd_sc_hd__fill_2
XFILLER_20_51 VGND VGND VPWR VPWR sky130_fd_sc_hd__fill_1
XFILLER_4_268 VGND VGND VPWR VPWR sky130_fd_sc_hd__decap_3
XFILLER_20_95 VGND VGND VPWR VPWR sky130_fd_sc_hd__decap_3
XFILLER_29_71 VGND VGND VPWR VPWR sky130_fd_sc_hd__decap_3
XFILLER_29_82 VGND VGND VPWR VPWR sky130_fd_sc_hd__decap_3
XFILLER_35_128 VGND VGND VPWR VPWR sky130_fd_sc_hd__decap_3
XFILLER_28_180 VGND VGND VPWR VPWR sky130_fd_sc_hd__decap_3
XFILLER_50_109 VGND VGND VPWR VPWR sky130_fd_sc_hd__fill_2
XFILLER_45_70 VGND VGND VPWR VPWR sky130_fd_sc_hd__decap_3
XTAP_TAPCELL_ROW_33_329 VGND VPWR sky130_fd_sc_hd__tapvpwrvgnd_1
XFILLER_43_194 VGND VGND VPWR VPWR sky130_fd_sc_hd__fill_2
XFILLER_43_183 VGND VGND VPWR VPWR sky130_fd_sc_hd__fill_1
XFILLER_43_172 VGND VGND VPWR VPWR sky130_fd_sc_hd__decap_3
X_2760_ _2761_/B _2760_/B VGND VGND VPWR VPWR _2776_/D sky130_fd_sc_hd__nor2_1
X_1711_ _1711_/A _1711_/B VGND VGND VPWR VPWR _1713_/C sky130_fd_sc_hd__xnor2_1
X_2691_ _2691_/A _2691_/B VGND VGND VPWR VPWR _2691_/Y sky130_fd_sc_hd__nand2_1
X_1642_ _1642_/A _1642_/B VGND VGND VPWR VPWR _1643_/C sky130_fd_sc_hd__or2_1
XFILLER_6_64 VGND VGND VPWR VPWR sky130_fd_sc_hd__decap_3
X_1573_ _1606_/A VGND VGND VPWR VPWR _1573_/Y sky130_fd_sc_hd__inv_2
XFILLER_3_290 VGND VGND VPWR VPWR sky130_fd_sc_hd__decap_3
X_2125_ _2121_/A _2121_/B _2124_/X VGND VGND VPWR VPWR _2130_/A sky130_fd_sc_hd__a21o_1
XFILLER_26_106 VGND VGND VPWR VPWR sky130_fd_sc_hd__decap_3
X_2056_ _2056_/A _2056_/B VGND VGND VPWR VPWR _2127_/A sky130_fd_sc_hd__xnor2_1
XFILLER_26_139 VGND VGND VPWR VPWR sky130_fd_sc_hd__fill_1
XFILLER_25_18 VGND VGND VPWR VPWR sky130_fd_sc_hd__decap_3
XFILLER_34_161 VGND VGND VPWR VPWR sky130_fd_sc_hd__decap_3
XFILLER_22_301 VGND VGND VPWR VPWR sky130_fd_sc_hd__decap_3
XFILLER_22_323 VGND VGND VPWR VPWR sky130_fd_sc_hd__decap_3
X_1909_ _1909_/A _1909_/B VGND VGND VPWR VPWR _1910_/B sky130_fd_sc_hd__xnor2_1
XFILLER_49_209 VGND VGND VPWR VPWR sky130_fd_sc_hd__decap_3
XFILLER_57_264 VGND VGND VPWR VPWR sky130_fd_sc_hd__decap_3
XFILLER_17_106 VGND VGND VPWR VPWR sky130_fd_sc_hd__fill_2
XFILLER_25_183 VGND VGND VPWR VPWR sky130_fd_sc_hd__decap_3
XFILLER_9_316 VGND VGND VPWR VPWR sky130_fd_sc_hd__decap_3
XFILLER_40_131 VGND VGND VPWR VPWR sky130_fd_sc_hd__decap_3
XFILLER_40_175 VGND VGND VPWR VPWR sky130_fd_sc_hd__decap_3
XFILLER_40_197 VGND VGND VPWR VPWR sky130_fd_sc_hd__fill_2
XFILLER_31_50 VGND VGND VPWR VPWR sky130_fd_sc_hd__decap_3
XFILLER_31_72 VGND VGND VPWR VPWR sky130_fd_sc_hd__decap_3
XPHY_EDGE_ROW_33_Left_94 VGND VGND VPWR VPWR sky130_fd_sc_hd__decap_3
XFILLER_49_9 VGND VGND VPWR VPWR sky130_fd_sc_hd__decap_3
XFILLER_48_253 VGND VGND VPWR VPWR sky130_fd_sc_hd__decap_3
XFILLER_16_183 VGND VGND VPWR VPWR sky130_fd_sc_hd__fill_1
XFILLER_16_161 VGND VGND VPWR VPWR sky130_fd_sc_hd__decap_3
XFILLER_31_186 VGND VGND VPWR VPWR sky130_fd_sc_hd__decap_3
XFILLER_31_153 VGND VGND VPWR VPWR sky130_fd_sc_hd__decap_3
X_2743_ _2743_/A _2746_/C VGND VGND VPWR VPWR _2766_/D sky130_fd_sc_hd__nor2_1
X_2674_ _2674_/A _2719_/B VGND VGND VPWR VPWR _2674_/Y sky130_fd_sc_hd__nor2_1
X_1625_ _1625_/A _1809_/A _1625_/C VGND VGND VPWR VPWR _1627_/B sky130_fd_sc_hd__or3_1
X_1556_ _1754_/A VGND VGND VPWR VPWR _1556_/Y sky130_fd_sc_hd__inv_2
X_1487_ _1899_/A _1683_/A _1692_/A VGND VGND VPWR VPWR _1641_/B sky130_fd_sc_hd__a21oi_1
XFILLER_39_231 VGND VGND VPWR VPWR sky130_fd_sc_hd__decap_3
XFILLER_39_275 VGND VGND VPWR VPWR sky130_fd_sc_hd__decap_3
X_2108_ _2108_/A _2108_/B VGND VGND VPWR VPWR _2145_/B sky130_fd_sc_hd__xor2_1
XFILLER_54_234 VGND VGND VPWR VPWR sky130_fd_sc_hd__decap_3
XFILLER_39_297 VGND VGND VPWR VPWR sky130_fd_sc_hd__decap_3
XFILLER_54_267 VGND VGND VPWR VPWR sky130_fd_sc_hd__decap_3
X_2039_ _2039_/A _2039_/B VGND VGND VPWR VPWR _2040_/B sky130_fd_sc_hd__xnor2_1
XFILLER_52_27 VGND VGND VPWR VPWR sky130_fd_sc_hd__fill_1
XFILLER_22_131 VGND VGND VPWR VPWR sky130_fd_sc_hd__decap_3
XTAP_TAPCELL_ROW_60_490 VGND VPWR sky130_fd_sc_hd__tapvpwrvgnd_1
XFILLER_22_197 VGND VGND VPWR VPWR sky130_fd_sc_hd__decap_3
XFILLER_45_256 VGND VGND VPWR VPWR sky130_fd_sc_hd__fill_1
XFILLER_60_237 VGND VGND VPWR VPWR sky130_fd_sc_hd__decap_3
XFILLER_60_215 VGND VGND VPWR VPWR sky130_fd_sc_hd__decap_3
XFILLER_60_259 VGND VGND VPWR VPWR sky130_fd_sc_hd__decap_3
XFILLER_13_175 VGND VGND VPWR VPWR sky130_fd_sc_hd__fill_1
XFILLER_13_186 VGND VGND VPWR VPWR sky130_fd_sc_hd__decap_3
XFILLER_42_71 VGND VGND VPWR VPWR sky130_fd_sc_hd__fill_1
X_1410_ _1410_/A _1410_/B VGND VGND VPWR VPWR _1411_/B sky130_fd_sc_hd__nand2_1
XFILLER_47_6 VGND VGND VPWR VPWR sky130_fd_sc_hd__decap_3
X_2390_ _2455_/B _2390_/B VGND VGND VPWR VPWR _2427_/A sky130_fd_sc_hd__or2_1
XFILLER_3_21 VGND VGND VPWR VPWR sky130_fd_sc_hd__decap_3
XFILLER_3_65 VGND VGND VPWR VPWR sky130_fd_sc_hd__decap_3
XFILLER_3_54 VGND VGND VPWR VPWR sky130_fd_sc_hd__fill_2
XFILLER_3_98 VGND VGND VPWR VPWR sky130_fd_sc_hd__decap_3
XFILLER_36_234 VGND VGND VPWR VPWR sky130_fd_sc_hd__decap_3
XFILLER_36_256 VGND VGND VPWR VPWR sky130_fd_sc_hd__decap_3
X_2726_ _2726_/A _2749_/B VGND VGND VPWR VPWR _2752_/B sky130_fd_sc_hd__nor2_1
X_2657_ _2657_/A _2657_/B _2596_/X VGND VGND VPWR VPWR _2657_/X sky130_fd_sc_hd__or3b_1
X_1608_ _1671_/A _1608_/B VGND VGND VPWR VPWR _1637_/B sky130_fd_sc_hd__xnor2_1
X_2588_ _2634_/A _2587_/B _2538_/X VGND VGND VPWR VPWR _2637_/A sky130_fd_sc_hd__a21o_1
X_1539_ _1558_/B _1539_/B VGND VGND VPWR VPWR _1542_/C sky130_fd_sc_hd__xnor2_1
XFILLER_59_337 VGND VGND VPWR VPWR sky130_fd_sc_hd__decap_3
XFILLER_59_326 VGND VGND VPWR VPWR sky130_fd_sc_hd__decap_3
XFILLER_47_27 VGND VGND VPWR VPWR sky130_fd_sc_hd__decap_3
XFILLER_47_49 VGND VGND VPWR VPWR sky130_fd_sc_hd__decap_3
XFILLER_42_204 VGND VGND VPWR VPWR sky130_fd_sc_hd__decap_3
XFILLER_10_101 VGND VGND VPWR VPWR sky130_fd_sc_hd__decap_3
XFILLER_50_292 VGND VGND VPWR VPWR sky130_fd_sc_hd__decap_3
XFILLER_6_105 VGND VGND VPWR VPWR sky130_fd_sc_hd__decap_3
XFILLER_6_138 VGND VGND VPWR VPWR sky130_fd_sc_hd__fill_2
XFILLER_12_85 VGND VGND VPWR VPWR sky130_fd_sc_hd__decap_3
XTAP_TAPCELL_ROW_5_160 VGND VPWR sky130_fd_sc_hd__tapvpwrvgnd_1
XPHY_EDGE_ROW_16_Right_16 VGND VGND VPWR VPWR sky130_fd_sc_hd__decap_3
XFILLER_33_204 VGND VGND VPWR VPWR sky130_fd_sc_hd__fill_2
X_1890_ _1890_/A _1890_/B VGND VGND VPWR VPWR _1892_/B sky130_fd_sc_hd__xnor2_1
XFILLER_41_270 VGND VGND VPWR VPWR sky130_fd_sc_hd__decap_3
XPHY_EDGE_ROW_25_Right_25 VGND VGND VPWR VPWR sky130_fd_sc_hd__decap_3
X_2511_ _2512_/B _2663_/A VGND VGND VPWR VPWR _2514_/A sky130_fd_sc_hd__xor2_1
XTAP_TAPCELL_ROW_11_195 VGND VPWR sky130_fd_sc_hd__tapvpwrvgnd_1
X_2442_ _2442_/A VGND VGND VPWR VPWR _2445_/B sky130_fd_sc_hd__inv_2
XFILLER_45_3 VGND VGND VPWR VPWR sky130_fd_sc_hd__decap_3
X_2373_ _2371_/X _2372_/X _2017_/Y VGND VGND VPWR VPWR _2417_/A sky130_fd_sc_hd__a21bo_2
XFILLER_56_318 VGND VGND VPWR VPWR sky130_fd_sc_hd__decap_3
XFILLER_56_307 VGND VGND VPWR VPWR sky130_fd_sc_hd__fill_1
XPHY_EDGE_ROW_34_Right_34 VGND VGND VPWR VPWR sky130_fd_sc_hd__decap_3
XPHY_EDGE_ROW_20_Left_81 VGND VGND VPWR VPWR sky130_fd_sc_hd__decap_3
XFILLER_24_226 VGND VGND VPWR VPWR sky130_fd_sc_hd__decap_3
XFILLER_24_248 VGND VGND VPWR VPWR sky130_fd_sc_hd__decap_3
XPHY_EDGE_ROW_43_Right_43 VGND VGND VPWR VPWR sky130_fd_sc_hd__decap_3
X_2709_ _2669_/B _2707_/Y _2708_/X _2696_/A _2651_/Y VGND VGND VPWR VPWR _2709_/X
+ sky130_fd_sc_hd__o2111a_1
XFILLER_3_119 VGND VGND VPWR VPWR sky130_fd_sc_hd__decap_3
XFILLER_58_15 VGND VGND VPWR VPWR sky130_fd_sc_hd__decap_3
XFILLER_59_123 VGND VGND VPWR VPWR sky130_fd_sc_hd__fill_1
XFILLER_58_59 VGND VGND VPWR VPWR sky130_fd_sc_hd__decap_3
XPHY_EDGE_ROW_52_Right_52 VGND VGND VPWR VPWR sky130_fd_sc_hd__decap_3
XFILLER_47_329 VGND VGND VPWR VPWR sky130_fd_sc_hd__decap_3
XTAP_TAPCELL_ROW_2_141 VGND VPWR sky130_fd_sc_hd__tapvpwrvgnd_1
XFILLER_55_340 VGND VGND VPWR VPWR sky130_fd_sc_hd__decap_3
XFILLER_15_237 VGND VGND VPWR VPWR sky130_fd_sc_hd__decap_3
XFILLER_30_218 VGND VGND VPWR VPWR sky130_fd_sc_hd__decap_3
XFILLER_23_281 VGND VGND VPWR VPWR sky130_fd_sc_hd__decap_3
XFILLER_2_174 VGND VGND VPWR VPWR sky130_fd_sc_hd__decap_3
XFILLER_2_141 VGND VGND VPWR VPWR sky130_fd_sc_hd__fill_2
XFILLER_38_318 VGND VGND VPWR VPWR sky130_fd_sc_hd__decap_3
XFILLER_38_307 VGND VGND VPWR VPWR sky130_fd_sc_hd__fill_1
XFILLER_46_340 VGND VGND VPWR VPWR sky130_fd_sc_hd__decap_3
X_1942_ _2016_/A _2016_/B VGND VGND VPWR VPWR _2374_/A sky130_fd_sc_hd__nor2_2
XFILLER_9_53 VGND VGND VPWR VPWR sky130_fd_sc_hd__decap_3
X_1873_ _1944_/A _1873_/B VGND VGND VPWR VPWR _1874_/B sky130_fd_sc_hd__or2_1
X_2425_ _2460_/A _2653_/B _2512_/B VGND VGND VPWR VPWR _2426_/B sky130_fd_sc_hd__and3_1
X_2356_ _2356_/A _2356_/B _2356_/C VGND VGND VPWR VPWR _2356_/X sky130_fd_sc_hd__and3_1
XFILLER_56_104 VGND VGND VPWR VPWR sky130_fd_sc_hd__decap_3
XFILLER_28_29 VGND VGND VPWR VPWR sky130_fd_sc_hd__decap_3
X_2287_ _2309_/A _2309_/B VGND VGND VPWR VPWR _2290_/A sky130_fd_sc_hd__nor2_1
XFILLER_56_137 VGND VGND VPWR VPWR sky130_fd_sc_hd__decap_3
XFILLER_56_159 VGND VGND VPWR VPWR sky130_fd_sc_hd__decap_3
XFILLER_37_340 VGND VGND VPWR VPWR sky130_fd_sc_hd__decap_3
XFILLER_52_321 VGND VGND VPWR VPWR sky130_fd_sc_hd__decap_3
XFILLER_52_354 VGND VGND VPWR VPWR sky130_fd_sc_hd__decap_3
XFILLER_60_27 VGND VGND VPWR VPWR sky130_fd_sc_hd__fill_1
XFILLER_60_38 VGND VGND VPWR VPWR sky130_fd_sc_hd__decap_3
XFILLER_55_181 VGND VGND VPWR VPWR sky130_fd_sc_hd__decap_3
XFILLER_43_321 VGND VGND VPWR VPWR sky130_fd_sc_hd__decap_3
XFILLER_43_354 VGND VGND VPWR VPWR sky130_fd_sc_hd__decap_3
XFILLER_34_72 VGND VGND VPWR VPWR sky130_fd_sc_hd__decap_3
XFILLER_11_240 VGND VGND VPWR VPWR sky130_fd_sc_hd__decap_3
XFILLER_34_94 VGND VGND VPWR VPWR sky130_fd_sc_hd__decap_3
XFILLER_7_222 VGND VGND VPWR VPWR sky130_fd_sc_hd__fill_2
XFILLER_7_200 VGND VGND VPWR VPWR sky130_fd_sc_hd__decap_3
XFILLER_7_266 VGND VGND VPWR VPWR sky130_fd_sc_hd__fill_2
XFILLER_50_71 VGND VGND VPWR VPWR sky130_fd_sc_hd__decap_3
X_2210_ _2210_/A _2210_/B VGND VGND VPWR VPWR _2211_/B sky130_fd_sc_hd__xnor2_1
X_2141_ _2144_/A _2144_/B _2139_/Y VGND VGND VPWR VPWR _2143_/B sky130_fd_sc_hd__o21a_1
XFILLER_38_115 VGND VGND VPWR VPWR sky130_fd_sc_hd__decap_3
X_2072_ _2138_/A _2138_/B VGND VGND VPWR VPWR _2073_/B sky130_fd_sc_hd__nand2b_1
XFILLER_53_107 VGND VGND VPWR VPWR sky130_fd_sc_hd__decap_3
XTAP_TAPCELL_ROW_36_349 VGND VPWR sky130_fd_sc_hd__tapvpwrvgnd_1
X_1925_ _1926_/A _1926_/B VGND VGND VPWR VPWR _1925_/Y sky130_fd_sc_hd__nand2_1
XTAP_TAPCELL_ROW_44_393 VGND VPWR sky130_fd_sc_hd__tapvpwrvgnd_1
X_1856_ _1856_/A _1856_/B _1856_/C VGND VGND VPWR VPWR _1857_/B sky130_fd_sc_hd__and3_1
X_1787_ _1787_/A _1787_/B _1784_/Y VGND VGND VPWR VPWR _1788_/B sky130_fd_sc_hd__or3b_1
Xtt_um_connerdaehler_boop_52 VGND VGND VPWR VPWR tt_um_connerdaehler_boop_52/HI uio_oe[3]
+ sky130_fd_sc_hd__conb_1
Xtt_um_connerdaehler_boop_63 VGND VGND VPWR VPWR tt_um_connerdaehler_boop_63/HI uio_out[6]
+ sky130_fd_sc_hd__conb_1
XFILLER_39_39 VGND VGND VPWR VPWR sky130_fd_sc_hd__decap_3
X_2408_ _2427_/B _2408_/B VGND VGND VPWR VPWR _2431_/C sky130_fd_sc_hd__and2_1
X_2339_ _2264_/A _2726_/A _2214_/X _2292_/A VGND VGND VPWR VPWR _2341_/B sky130_fd_sc_hd__o211a_1
XPHY_EDGE_ROW_2_Right_2 VGND VGND VPWR VPWR sky130_fd_sc_hd__decap_3
XFILLER_29_137 VGND VGND VPWR VPWR sky130_fd_sc_hd__decap_3
XFILLER_55_27 VGND VGND VPWR VPWR sky130_fd_sc_hd__decap_3
XFILLER_25_332 VGND VGND VPWR VPWR sky130_fd_sc_hd__decap_3
XFILLER_52_162 VGND VGND VPWR VPWR sky130_fd_sc_hd__decap_3
XFILLER_52_195 VGND VGND VPWR VPWR sky130_fd_sc_hd__fill_1
XFILLER_4_203 VGND VGND VPWR VPWR sky130_fd_sc_hd__decap_3
XFILLER_20_85 VGND VGND VPWR VPWR sky130_fd_sc_hd__fill_2
XFILLER_20_63 VGND VGND VPWR VPWR sky130_fd_sc_hd__fill_1
XPHY_EDGE_ROW_42_Left_103 VGND VGND VPWR VPWR sky130_fd_sc_hd__decap_3
XFILLER_29_94 VGND VGND VPWR VPWR sky130_fd_sc_hd__decap_3
XFILLER_35_107 VGND VGND VPWR VPWR sky130_fd_sc_hd__decap_3
XFILLER_28_192 VGND VGND VPWR VPWR sky130_fd_sc_hd__decap_3
XFILLER_43_151 VGND VGND VPWR VPWR sky130_fd_sc_hd__decap_3
XPHY_EDGE_ROW_51_Left_112 VGND VGND VPWR VPWR sky130_fd_sc_hd__decap_3
XTAP_TAPCELL_ROW_41_374 VGND VPWR sky130_fd_sc_hd__tapvpwrvgnd_1
X_1710_ _1849_/A _1849_/B VGND VGND VPWR VPWR _1713_/B sky130_fd_sc_hd__nand2b_1
X_2690_ input6/X _2690_/B VGND VGND VPWR VPWR uo_out[2] sky130_fd_sc_hd__xor2_4
X_1641_ _1488_/B _1641_/B VGND VGND VPWR VPWR _1642_/B sky130_fd_sc_hd__and2b_1
XFILLER_6_32 VGND VGND VPWR VPWR sky130_fd_sc_hd__fill_2
XFILLER_6_21 VGND VGND VPWR VPWR sky130_fd_sc_hd__decap_3
X_1572_ _1586_/A _1572_/B _1572_/C VGND VGND VPWR VPWR _1606_/A sky130_fd_sc_hd__and3_1
XPHY_EDGE_ROW_60_Left_121 VGND VGND VPWR VPWR sky130_fd_sc_hd__decap_3
X_2124_ _2177_/A _2177_/B VGND VGND VPWR VPWR _2124_/X sky130_fd_sc_hd__and2b_1
X_2055_ _2055_/A _2055_/B VGND VGND VPWR VPWR _2056_/B sky130_fd_sc_hd__nor2_1
XFILLER_34_151 VGND VGND VPWR VPWR sky130_fd_sc_hd__decap_3
XFILLER_41_18 VGND VGND VPWR VPWR sky130_fd_sc_hd__decap_3
X_1908_ _1909_/B _1909_/A VGND VGND VPWR VPWR _1908_/X sky130_fd_sc_hd__and2b_1
X_1839_ _1986_/B _2217_/B _1839_/C VGND VGND VPWR VPWR _1841_/A sky130_fd_sc_hd__and3_1
XFILLER_9_9 VGND VGND VPWR VPWR sky130_fd_sc_hd__decap_3
XFILLER_57_243 VGND VGND VPWR VPWR sky130_fd_sc_hd__decap_3
XFILLER_57_287 VGND VGND VPWR VPWR sky130_fd_sc_hd__decap_3
XFILLER_57_276 VGND VGND VPWR VPWR sky130_fd_sc_hd__decap_3
XFILLER_25_140 VGND VGND VPWR VPWR sky130_fd_sc_hd__decap_3
XFILLER_13_324 VGND VGND VPWR VPWR sky130_fd_sc_hd__decap_3
XFILLER_40_110 VGND VGND VPWR VPWR sky130_fd_sc_hd__decap_3
XFILLER_15_30 VGND VGND VPWR VPWR sky130_fd_sc_hd__decap_3
XFILLER_13_346 VGND VGND VPWR VPWR sky130_fd_sc_hd__decap_3
XFILLER_15_85 VGND VGND VPWR VPWR sky130_fd_sc_hd__decap_3
XFILLER_40_187 VGND VGND VPWR VPWR sky130_fd_sc_hd__decap_3
XFILLER_31_84 VGND VGND VPWR VPWR sky130_fd_sc_hd__decap_3
XFILLER_48_287 VGND VGND VPWR VPWR sky130_fd_sc_hd__decap_3
XFILLER_31_110 VGND VGND VPWR VPWR sky130_fd_sc_hd__fill_2
XFILLER_31_132 VGND VGND VPWR VPWR sky130_fd_sc_hd__decap_3
XFILLER_31_165 VGND VGND VPWR VPWR sky130_fd_sc_hd__decap_3
X_2742_ _2742_/A _2742_/B VGND VGND VPWR VPWR _2746_/C sky130_fd_sc_hd__and2_1
XFILLER_31_198 VGND VGND VPWR VPWR sky130_fd_sc_hd__decap_3
X_2673_ _2673_/A _2673_/B VGND VGND VPWR VPWR _2673_/X sky130_fd_sc_hd__or2_1
X_1624_ _1624_/A _1624_/B VGND VGND VPWR VPWR _1625_/C sky130_fd_sc_hd__nor2_1
X_1555_ _1813_/A _1553_/B _1569_/A VGND VGND VPWR VPWR _1754_/A sky130_fd_sc_hd__a21oi_4
X_1486_ _1820_/B _1704_/B VGND VGND VPWR VPWR _1683_/A sky130_fd_sc_hd__nor2_1
XFILLER_39_243 VGND VGND VPWR VPWR sky130_fd_sc_hd__fill_2
XFILLER_39_221 VGND VGND VPWR VPWR sky130_fd_sc_hd__decap_3
XFILLER_39_254 VGND VGND VPWR VPWR sky130_fd_sc_hd__decap_3
XFILLER_36_18 VGND VGND VPWR VPWR sky130_fd_sc_hd__decap_3
X_2107_ _2126_/B _2107_/B VGND VGND VPWR VPWR _2145_/A sky130_fd_sc_hd__and2_1
XFILLER_54_213 VGND VGND VPWR VPWR sky130_fd_sc_hd__decap_3
XFILLER_39_287 VGND VGND VPWR VPWR sky130_fd_sc_hd__fill_1
X_2038_ _2039_/A _2039_/B VGND VGND VPWR VPWR _2038_/Y sky130_fd_sc_hd__nand2b_1
XFILLER_54_279 VGND VGND VPWR VPWR sky130_fd_sc_hd__decap_3
XFILLER_10_305 VGND VGND VPWR VPWR sky130_fd_sc_hd__decap_3
XFILLER_10_349 VGND VGND VPWR VPWR sky130_fd_sc_hd__decap_3
XTAP_TAPCELL_ROW_60_491 VGND VPWR sky130_fd_sc_hd__tapvpwrvgnd_1
XFILLER_6_309 VGND VGND VPWR VPWR sky130_fd_sc_hd__decap_3
XFILLER_7_6 VGND VGND VPWR VPWR sky130_fd_sc_hd__decap_3
XFILLER_45_235 VGND VGND VPWR VPWR sky130_fd_sc_hd__decap_3
XFILLER_45_279 VGND VGND VPWR VPWR sky130_fd_sc_hd__fill_1
XFILLER_26_73 VGND VGND VPWR VPWR sky130_fd_sc_hd__decap_3
XFILLER_26_62 VGND VGND VPWR VPWR sky130_fd_sc_hd__decap_3
XFILLER_60_249 VGND VGND VPWR VPWR sky130_fd_sc_hd__decap_3
XFILLER_53_290 VGND VGND VPWR VPWR sky130_fd_sc_hd__decap_3
XFILLER_13_165 VGND VGND VPWR VPWR sky130_fd_sc_hd__decap_3
XFILLER_13_198 VGND VGND VPWR VPWR sky130_fd_sc_hd__decap_3
XFILLER_9_158 VGND VGND VPWR VPWR sky130_fd_sc_hd__decap_3
XFILLER_9_169 VGND VGND VPWR VPWR sky130_fd_sc_hd__fill_1
XFILLER_42_94 VGND VGND VPWR VPWR sky130_fd_sc_hd__decap_3
XFILLER_5_331 VGND VGND VPWR VPWR sky130_fd_sc_hd__decap_3
XTAP_TAPCELL_ROW_8_180 VGND VPWR sky130_fd_sc_hd__tapvpwrvgnd_1
XFILLER_3_33 VGND VGND VPWR VPWR sky130_fd_sc_hd__decap_3
XFILLER_3_77 VGND VGND VPWR VPWR sky130_fd_sc_hd__decap_3
XFILLER_36_224 VGND VGND VPWR VPWR sky130_fd_sc_hd__fill_1
XFILLER_36_268 VGND VGND VPWR VPWR sky130_fd_sc_hd__decap_3
XFILLER_36_246 VGND VGND VPWR VPWR sky130_fd_sc_hd__fill_2
X_2725_ input5/X input1/X VGND VGND VPWR VPWR _2749_/B sky130_fd_sc_hd__nand2b_1
XFILLER_8_180 VGND VGND VPWR VPWR sky130_fd_sc_hd__decap_3
X_2656_ _2662_/A _2656_/B VGND VGND VPWR VPWR _2656_/Y sky130_fd_sc_hd__nor2_1
X_1607_ _1607_/A _1607_/B VGND VGND VPWR VPWR _1637_/A sky130_fd_sc_hd__xnor2_1
X_2587_ _2538_/X _2587_/B VGND VGND VPWR VPWR _2634_/B sky130_fd_sc_hd__nand2b_1
X_1538_ _1538_/A _1538_/B VGND VGND VPWR VPWR _1539_/B sky130_fd_sc_hd__nor2_1
XFILLER_59_305 VGND VGND VPWR VPWR sky130_fd_sc_hd__decap_3
X_1469_ _1535_/A _1469_/B VGND VGND VPWR VPWR _1470_/B sky130_fd_sc_hd__or2_1
XFILLER_59_349 VGND VGND VPWR VPWR sky130_fd_sc_hd__decap_3
XFILLER_27_202 VGND VGND VPWR VPWR sky130_fd_sc_hd__decap_3
XFILLER_27_268 VGND VGND VPWR VPWR sky130_fd_sc_hd__decap_3
XFILLER_27_279 VGND VGND VPWR VPWR sky130_fd_sc_hd__fill_1
XFILLER_42_249 VGND VGND VPWR VPWR sky130_fd_sc_hd__decap_3
XFILLER_10_113 VGND VGND VPWR VPWR sky130_fd_sc_hd__decap_3
XFILLER_50_271 VGND VGND VPWR VPWR sky130_fd_sc_hd__decap_3
XFILLER_12_64 VGND VGND VPWR VPWR sky130_fd_sc_hd__decap_3
XFILLER_12_97 VGND VGND VPWR VPWR sky130_fd_sc_hd__decap_3
XFILLER_2_301 VGND VGND VPWR VPWR sky130_fd_sc_hd__decap_3
XFILLER_5_3 VGND VGND VPWR VPWR sky130_fd_sc_hd__decap_3
XFILLER_2_334 VGND VGND VPWR VPWR sky130_fd_sc_hd__fill_1
XTAP_TAPCELL_ROW_5_161 VGND VPWR sky130_fd_sc_hd__tapvpwrvgnd_1
XFILLER_58_360 VGND VGND VPWR VPWR sky130_fd_sc_hd__fill_1
XFILLER_18_235 VGND VGND VPWR VPWR sky130_fd_sc_hd__decap_3
XTAP_TAPCELL_ROW_28_296 VGND VPWR sky130_fd_sc_hd__tapvpwrvgnd_1
XFILLER_33_249 VGND VGND VPWR VPWR sky130_fd_sc_hd__fill_1
XFILLER_26_290 VGND VGND VPWR VPWR sky130_fd_sc_hd__fill_2
X_2510_ _2595_/A _2595_/B VGND VGND VPWR VPWR _2510_/Y sky130_fd_sc_hd__nor2_1
XTAP_TAPCELL_ROW_11_196 VGND VPWR sky130_fd_sc_hd__tapvpwrvgnd_1
X_2441_ _2441_/A _2441_/B VGND VGND VPWR VPWR _2442_/A sky130_fd_sc_hd__xnor2_1
XFILLER_5_172 VGND VGND VPWR VPWR sky130_fd_sc_hd__decap_3
X_2372_ _2372_/A _2372_/B VGND VGND VPWR VPWR _2372_/X sky130_fd_sc_hd__or2_1
XFILLER_38_3 VGND VGND VPWR VPWR sky130_fd_sc_hd__decap_3
XFILLER_17_290 VGND VGND VPWR VPWR sky130_fd_sc_hd__decap_3
XFILLER_32_271 VGND VGND VPWR VPWR sky130_fd_sc_hd__fill_1
X_2708_ _1489_/B _2457_/A _2457_/B _2719_/B VGND VGND VPWR VPWR _2708_/X sky130_fd_sc_hd__a211o_1
X_2639_ _2649_/A _2640_/D VGND VGND VPWR VPWR _2661_/S sky130_fd_sc_hd__nand2_1
XFILLER_59_102 VGND VGND VPWR VPWR sky130_fd_sc_hd__fill_1
XFILLER_58_38 VGND VGND VPWR VPWR sky130_fd_sc_hd__decap_3
XFILLER_58_27 VGND VGND VPWR VPWR sky130_fd_sc_hd__fill_1
XFILLER_59_135 VGND VGND VPWR VPWR sky130_fd_sc_hd__decap_3
XFILLER_59_157 VGND VGND VPWR VPWR sky130_fd_sc_hd__fill_2
XFILLER_47_308 VGND VGND VPWR VPWR sky130_fd_sc_hd__decap_3
XTAP_TAPCELL_ROW_2_142 VGND VPWR sky130_fd_sc_hd__tapvpwrvgnd_1
XFILLER_55_352 VGND VGND VPWR VPWR sky130_fd_sc_hd__decap_3
XFILLER_15_249 VGND VGND VPWR VPWR sky130_fd_sc_hd__decap_3
XFILLER_23_271 VGND VGND VPWR VPWR sky130_fd_sc_hd__decap_3
XFILLER_23_63 VGND VGND VPWR VPWR sky130_fd_sc_hd__decap_3
XFILLER_23_52 VGND VGND VPWR VPWR sky130_fd_sc_hd__decap_3
XFILLER_23_96 VGND VGND VPWR VPWR sky130_fd_sc_hd__decap_3
XFILLER_2_153 VGND VGND VPWR VPWR sky130_fd_sc_hd__decap_3
XFILLER_0_12 VGND VGND VPWR VPWR sky130_fd_sc_hd__decap_3
XFILLER_46_352 VGND VGND VPWR VPWR sky130_fd_sc_hd__decap_3
XFILLER_0_67 VGND VGND VPWR VPWR sky130_fd_sc_hd__decap_3
XFILLER_0_89 VGND VGND VPWR VPWR sky130_fd_sc_hd__decap_3
XFILLER_21_208 VGND VGND VPWR VPWR sky130_fd_sc_hd__decap_3
X_1941_ _1941_/A _1941_/B VGND VGND VPWR VPWR _2016_/B sky130_fd_sc_hd__xnor2_2
XFILLER_14_271 VGND VGND VPWR VPWR sky130_fd_sc_hd__decap_3
X_1872_ _1944_/A _1873_/B VGND VGND VPWR VPWR _1874_/A sky130_fd_sc_hd__nand2_1
XFILLER_14_293 VGND VGND VPWR VPWR sky130_fd_sc_hd__decap_3
X_2424_ _2426_/A _2663_/A _2643_/A VGND VGND VPWR VPWR _2656_/B sky130_fd_sc_hd__a21o_1
X_2355_ _2355_/A _2355_/B VGND VGND VPWR VPWR _2485_/A sky130_fd_sc_hd__xor2_1
XFILLER_29_308 VGND VGND VPWR VPWR sky130_fd_sc_hd__decap_3
XFILLER_28_19 VGND VGND VPWR VPWR sky130_fd_sc_hd__decap_3
X_2286_ _2286_/A _2286_/B VGND VGND VPWR VPWR _2309_/B sky130_fd_sc_hd__xor2_2
XFILLER_56_116 VGND VGND VPWR VPWR sky130_fd_sc_hd__decap_3
XFILLER_37_330 VGND VGND VPWR VPWR sky130_fd_sc_hd__decap_3
XFILLER_52_333 VGND VGND VPWR VPWR sky130_fd_sc_hd__decap_3
XFILLER_44_29 VGND VGND VPWR VPWR sky130_fd_sc_hd__decap_3
XFILLER_44_18 VGND VGND VPWR VPWR sky130_fd_sc_hd__decap_3
XFILLER_47_116 VGND VGND VPWR VPWR sky130_fd_sc_hd__decap_3
XFILLER_47_138 VGND VGND VPWR VPWR sky130_fd_sc_hd__fill_1
XFILLER_28_352 VGND VGND VPWR VPWR sky130_fd_sc_hd__decap_3
XFILLER_18_85 VGND VGND VPWR VPWR sky130_fd_sc_hd__decap_3
XFILLER_55_193 VGND VGND VPWR VPWR sky130_fd_sc_hd__decap_3
XFILLER_11_252 VGND VGND VPWR VPWR sky130_fd_sc_hd__decap_3
XFILLER_7_212 VGND VGND VPWR VPWR sky130_fd_sc_hd__decap_3
XFILLER_7_234 VGND VGND VPWR VPWR sky130_fd_sc_hd__decap_3
XFILLER_7_289 VGND VGND VPWR VPWR sky130_fd_sc_hd__decap_3
XFILLER_50_94 VGND VGND VPWR VPWR sky130_fd_sc_hd__fill_2
XFILLER_59_81 VGND VGND VPWR VPWR sky130_fd_sc_hd__decap_3
X_2140_ _2140_/A _2140_/B VGND VGND VPWR VPWR _2144_/B sky130_fd_sc_hd__xnor2_1
XFILLER_38_127 VGND VGND VPWR VPWR sky130_fd_sc_hd__fill_1
X_2071_ _2071_/A _2071_/B VGND VGND VPWR VPWR _2138_/B sky130_fd_sc_hd__xnor2_1
XFILLER_38_149 VGND VGND VPWR VPWR sky130_fd_sc_hd__fill_2
XFILLER_38_138 VGND VGND VPWR VPWR sky130_fd_sc_hd__fill_2
XFILLER_46_171 VGND VGND VPWR VPWR sky130_fd_sc_hd__decap_3
XFILLER_34_333 VGND VGND VPWR VPWR sky130_fd_sc_hd__decap_3
X_1924_ _1924_/A _1924_/B VGND VGND VPWR VPWR _1926_/B sky130_fd_sc_hd__xnor2_1
XTAP_TAPCELL_ROW_44_394 VGND VPWR sky130_fd_sc_hd__tapvpwrvgnd_1
X_1855_ _1856_/A _1856_/B _1856_/C VGND VGND VPWR VPWR _1865_/A sky130_fd_sc_hd__a21oi_1
X_1786_ _1549_/A _1549_/B _1547_/A VGND VGND VPWR VPWR _1791_/A sky130_fd_sc_hd__a21o_1
Xtt_um_connerdaehler_boop_53 VGND VGND VPWR VPWR tt_um_connerdaehler_boop_53/HI uio_oe[4]
+ sky130_fd_sc_hd__conb_1
XFILLER_39_18 VGND VGND VPWR VPWR sky130_fd_sc_hd__decap_3
X_2407_ _2407_/A _2490_/A VGND VGND VPWR VPWR _2408_/B sky130_fd_sc_hd__or2_1
Xtt_um_connerdaehler_boop_64 VGND VGND VPWR VPWR tt_um_connerdaehler_boop_64/HI uio_out[7]
+ sky130_fd_sc_hd__conb_1
X_2338_ _2338_/A _2338_/B _2338_/C VGND VGND VPWR VPWR _2341_/A sky130_fd_sc_hd__nand3_1
XFILLER_29_116 VGND VGND VPWR VPWR sky130_fd_sc_hd__decap_3
X_2269_ _2269_/A _2269_/B VGND VGND VPWR VPWR _2270_/B sky130_fd_sc_hd__xnor2_1
XFILLER_55_39 VGND VGND VPWR VPWR sky130_fd_sc_hd__decap_3
XFILLER_44_108 VGND VGND VPWR VPWR sky130_fd_sc_hd__decap_3
XFILLER_37_182 VGND VGND VPWR VPWR sky130_fd_sc_hd__decap_3
XFILLER_25_311 VGND VGND VPWR VPWR sky130_fd_sc_hd__decap_3
XFILLER_52_141 VGND VGND VPWR VPWR sky130_fd_sc_hd__decap_3
XFILLER_52_130 VGND VGND VPWR VPWR sky130_fd_sc_hd__decap_3
XFILLER_52_174 VGND VGND VPWR VPWR sky130_fd_sc_hd__decap_3
XFILLER_40_358 VGND VGND VPWR VPWR sky130_fd_sc_hd__decap_3
XFILLER_4_215 VGND VGND VPWR VPWR sky130_fd_sc_hd__decap_3
XFILLER_4_248 VGND VGND VPWR VPWR sky130_fd_sc_hd__decap_3
XFILLER_4_259 VGND VGND VPWR VPWR sky130_fd_sc_hd__fill_1
XFILLER_35_119 VGND VGND VPWR VPWR sky130_fd_sc_hd__decap_3
XFILLER_43_130 VGND VGND VPWR VPWR sky130_fd_sc_hd__decap_3
XFILLER_43_163 VGND VGND VPWR VPWR sky130_fd_sc_hd__decap_3
XFILLER_31_325 VGND VGND VPWR VPWR sky130_fd_sc_hd__decap_3
XFILLER_31_358 VGND VGND VPWR VPWR sky130_fd_sc_hd__decap_3
XTAP_TAPCELL_ROW_41_375 VGND VPWR sky130_fd_sc_hd__tapvpwrvgnd_1
X_1640_ _1640_/A _1640_/B _1640_/C VGND VGND VPWR VPWR _1643_/B sky130_fd_sc_hd__nor3_1
X_1571_ _2284_/A _1586_/B VGND VGND VPWR VPWR _1572_/C sky130_fd_sc_hd__nand2_1
XFILLER_6_99 VGND VGND VPWR VPWR sky130_fd_sc_hd__decap_3
XFILLER_6_88 VGND VGND VPWR VPWR sky130_fd_sc_hd__fill_1
XFILLER_6_77 VGND VGND VPWR VPWR sky130_fd_sc_hd__decap_3
XFILLER_3_270 VGND VGND VPWR VPWR sky130_fd_sc_hd__decap_3
XFILLER_20_3 VGND VGND VPWR VPWR sky130_fd_sc_hd__decap_3
X_2123_ _2122_/Y _1557_/B _2123_/S VGND VGND VPWR VPWR _2177_/B sky130_fd_sc_hd__mux2_1
X_2054_ _2054_/A _2054_/B _2054_/C VGND VGND VPWR VPWR _2055_/B sky130_fd_sc_hd__nor3_1
XFILLER_19_160 VGND VGND VPWR VPWR sky130_fd_sc_hd__fill_1
XFILLER_19_193 VGND VGND VPWR VPWR sky130_fd_sc_hd__decap_3
XFILLER_22_314 VGND VGND VPWR VPWR sky130_fd_sc_hd__decap_3
XTAP_TAPCELL_ROW_32_320 VGND VPWR sky130_fd_sc_hd__tapvpwrvgnd_1
X_1907_ _1907_/A _1907_/B VGND VGND VPWR VPWR _1909_/B sky130_fd_sc_hd__xnor2_1
X_1838_ _1444_/Y _1451_/X _1681_/B _1450_/X VGND VGND VPWR VPWR _1839_/C sky130_fd_sc_hd__o211a_1
X_1769_ _1760_/Y _1782_/A _1751_/Y VGND VGND VPWR VPWR _1780_/B sky130_fd_sc_hd__a21o_1
XFILLER_57_200 VGND VGND VPWR VPWR sky130_fd_sc_hd__fill_2
XFILLER_57_222 VGND VGND VPWR VPWR sky130_fd_sc_hd__fill_2
XFILLER_57_255 VGND VGND VPWR VPWR sky130_fd_sc_hd__decap_3
XFILLER_57_299 VGND VGND VPWR VPWR sky130_fd_sc_hd__decap_3
XFILLER_13_303 VGND VGND VPWR VPWR sky130_fd_sc_hd__decap_3
XFILLER_25_152 VGND VGND VPWR VPWR sky130_fd_sc_hd__decap_3
XFILLER_9_307 VGND VGND VPWR VPWR sky130_fd_sc_hd__decap_3
XFILLER_25_196 VGND VGND VPWR VPWR sky130_fd_sc_hd__decap_3
XFILLER_40_166 VGND VGND VPWR VPWR sky130_fd_sc_hd__decap_3
XFILLER_31_63 VGND VGND VPWR VPWR sky130_fd_sc_hd__decap_3
XFILLER_31_96 VGND VGND VPWR VPWR sky130_fd_sc_hd__decap_3
XFILLER_0_262 VGND VGND VPWR VPWR sky130_fd_sc_hd__decap_3
XFILLER_48_200 VGND VGND VPWR VPWR sky130_fd_sc_hd__decap_3
XFILLER_0_295 VGND VGND VPWR VPWR sky130_fd_sc_hd__decap_3
XFILLER_48_244 VGND VGND VPWR VPWR sky130_fd_sc_hd__decap_3
XFILLER_48_299 VGND VGND VPWR VPWR sky130_fd_sc_hd__decap_3
XFILLER_31_177 VGND VGND VPWR VPWR sky130_fd_sc_hd__decap_3
X_2741_ _2742_/A _2742_/B VGND VGND VPWR VPWR _2743_/A sky130_fd_sc_hd__nor2_1
XFILLER_8_340 VGND VGND VPWR VPWR sky130_fd_sc_hd__decap_3
X_2672_ _2672_/A _2672_/B _2672_/C _2644_/X VGND VGND VPWR VPWR _2672_/X sky130_fd_sc_hd__or4b_4
X_1623_ _1886_/A _2284_/A VGND VGND VPWR VPWR _1624_/B sky130_fd_sc_hd__nor2_1
X_1554_ _1671_/A _1568_/B VGND VGND VPWR VPWR _1569_/A sky130_fd_sc_hd__and2_1
X_1485_ _1690_/B _1690_/C _1693_/A VGND VGND VPWR VPWR _1692_/A sky130_fd_sc_hd__a21oi_1
XFILLER_39_200 VGND VGND VPWR VPWR sky130_fd_sc_hd__decap_3
.ends
